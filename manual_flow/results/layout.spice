* NGSPICE file created from axi2uart_bridge_top.ext - technology: sky130A

.subckt sky130_fd_sc_hd__decap_3 VPWR VGND VPB VNB
X0 VPWR VGND VPWR VPB sky130_fd_pr__pfet_01v8_hvt ad=0.2262 pd=2.26 as=0.4524 ps=4.52 w=0.87 l=0.59
X1 VGND VPWR VGND VNB sky130_fd_pr__nfet_01v8 ad=0.143 pd=1.62 as=0.286 ps=3.24 w=0.55 l=0.59
.ends

.subckt sky130_fd_sc_hd__dfrtp_1 VGND VPWR VPB VNB CLK D RESET_B Q
X0 a_1217_47# a_27_47# a_1108_47# VNB sky130_fd_pr__nfet_01v8 ad=0.0669 pd=0.75 as=0.0711 ps=0.755 w=0.36 l=0.15
X1 a_805_47# a_761_289# a_639_47# VNB sky130_fd_pr__nfet_01v8 ad=0.0441 pd=0.63 as=0.1401 ps=1.1 w=0.42 l=0.15
X2 a_1108_47# a_193_47# a_761_289# VNB sky130_fd_pr__nfet_01v8 ad=0.0711 pd=0.755 as=0.0999 ps=0.985 w=0.36 l=0.15
X3 a_1283_21# a_1108_47# a_1462_47# VNB sky130_fd_pr__nfet_01v8 ad=0.1092 pd=1.36 as=0.06405 ps=0.725 w=0.42 l=0.15
X4 a_651_413# a_27_47# a_543_47# VPB sky130_fd_pr__pfet_01v8_hvt ad=0.1155 pd=0.97 as=0.07245 ps=0.765 w=0.42 l=0.15
X5 VGND RESET_B a_805_47# VNB sky130_fd_pr__nfet_01v8 ad=0.1346 pd=1.15 as=0.0441 ps=0.63 w=0.42 l=0.15
X6 Q a_1283_21# VPWR VPB sky130_fd_pr__pfet_01v8_hvt ad=0.26 pd=2.52 as=0.3012 ps=2.66 w=1 l=0.15
X7 VPWR CLK a_27_47# VPB sky130_fd_pr__pfet_01v8_hvt ad=0.0864 pd=0.91 as=0.1664 ps=1.8 w=0.64 l=0.15
X8 a_448_47# D VPWR VPB sky130_fd_pr__pfet_01v8_hvt ad=0.0651 pd=0.73 as=0.1092 ps=1.36 w=0.42 l=0.15
X9 a_761_289# a_543_47# VGND VNB sky130_fd_pr__nfet_01v8 ad=0.0999 pd=0.985 as=0.1346 ps=1.15 w=0.64 l=0.15
X10 a_193_47# a_27_47# VGND VNB sky130_fd_pr__nfet_01v8 ad=0.1092 pd=1.36 as=0.0567 ps=0.69 w=0.42 l=0.15
X11 a_1108_47# a_27_47# a_761_289# VPB sky130_fd_pr__pfet_01v8_hvt ad=0.0588 pd=0.7 as=0.12915 ps=1.185 w=0.42 l=0.15
X12 a_543_47# a_27_47# a_448_47# VNB sky130_fd_pr__nfet_01v8 ad=0.0594 pd=0.69 as=0.066 ps=0.745 w=0.36 l=0.15
X13 a_1462_47# RESET_B VGND VNB sky130_fd_pr__nfet_01v8 ad=0.06405 pd=0.725 as=0.12495 ps=1.015 w=0.42 l=0.15
X14 a_543_47# a_193_47# a_448_47# VPB sky130_fd_pr__pfet_01v8_hvt ad=0.07245 pd=0.765 as=0.0651 ps=0.73 w=0.42 l=0.15
X15 a_448_47# D VGND VNB sky130_fd_pr__nfet_01v8 ad=0.066 pd=0.745 as=0.2205 ps=1.89 w=0.42 l=0.15
X16 VPWR a_1283_21# a_1270_413# VPB sky130_fd_pr__pfet_01v8_hvt ad=0.0819 pd=0.81 as=0.0567 ps=0.69 w=0.42 l=0.15
X17 VPWR a_1108_47# a_1283_21# VPB sky130_fd_pr__pfet_01v8_hvt ad=0.1134 pd=1.38 as=0.0567 ps=0.69 w=0.42 l=0.15
X18 a_1270_413# a_193_47# a_1108_47# VPB sky130_fd_pr__pfet_01v8_hvt ad=0.0567 pd=0.69 as=0.0588 ps=0.7 w=0.42 l=0.15
X19 a_193_47# a_27_47# VPWR VPB sky130_fd_pr__pfet_01v8_hvt ad=0.1664 pd=1.8 as=0.0864 ps=0.91 w=0.64 l=0.15
X20 a_1283_21# RESET_B VPWR VPB sky130_fd_pr__pfet_01v8_hvt ad=0.0567 pd=0.69 as=0.0819 ps=0.81 w=0.42 l=0.15
X21 VPWR a_761_289# a_651_413# VPB sky130_fd_pr__pfet_01v8_hvt ad=0.07035 pd=0.755 as=0.1155 ps=0.97 w=0.42 l=0.15
X22 Q a_1283_21# VGND VNB sky130_fd_pr__nfet_01v8 ad=0.169 pd=1.82 as=0.2087 ps=2.02 w=0.65 l=0.15
X23 a_639_47# a_193_47# a_543_47# VNB sky130_fd_pr__nfet_01v8 ad=0.1401 pd=1.1 as=0.0594 ps=0.69 w=0.36 l=0.15
X24 VGND a_1283_21# a_1217_47# VNB sky130_fd_pr__nfet_01v8 ad=0.12495 pd=1.015 as=0.0669 ps=0.75 w=0.42 l=0.15
X25 a_651_413# RESET_B VPWR VPB sky130_fd_pr__pfet_01v8_hvt ad=0.1092 pd=1.36 as=0.07035 ps=0.755 w=0.42 l=0.15
X26 VGND CLK a_27_47# VNB sky130_fd_pr__nfet_01v8 ad=0.0567 pd=0.69 as=0.1092 ps=1.36 w=0.42 l=0.15
X27 a_761_289# a_543_47# VPWR VPB sky130_fd_pr__pfet_01v8_hvt ad=0.12915 pd=1.185 as=0.2184 ps=2.2 w=0.84 l=0.15
.ends

.subckt sky130_fd_sc_hd__nor2_1 VPB VNB VGND VPWR A B Y
X0 VPWR A a_109_297# VPB sky130_fd_pr__pfet_01v8_hvt ad=0.26 pd=2.52 as=0.105 ps=1.21 w=1 l=0.15
X1 VGND A Y VNB sky130_fd_pr__nfet_01v8 ad=0.169 pd=1.82 as=0.08775 ps=0.92 w=0.65 l=0.15
X2 a_109_297# B Y VPB sky130_fd_pr__pfet_01v8_hvt ad=0.105 pd=1.21 as=0.26 ps=2.52 w=1 l=0.15
X3 Y B VGND VNB sky130_fd_pr__nfet_01v8 ad=0.08775 pd=0.92 as=0.169 ps=1.82 w=0.65 l=0.15
.ends

.subckt sky130_fd_sc_hd__o22ai_1 VPB VNB VGND VPWR A1 A2 B1 B2 Y
X0 VGND A2 a_27_47# VNB sky130_fd_pr__nfet_01v8 ad=0.08775 pd=0.92 as=0.115375 ps=1.005 w=0.65 l=0.15
X1 a_27_47# B2 Y VNB sky130_fd_pr__nfet_01v8 ad=0.115375 pd=1.005 as=0.092625 ps=0.935 w=0.65 l=0.15
X2 VPWR A1 a_307_297# VPB sky130_fd_pr__pfet_01v8_hvt ad=0.27 pd=2.54 as=0.105 ps=1.21 w=1 l=0.15
X3 a_307_297# A2 Y VPB sky130_fd_pr__pfet_01v8_hvt ad=0.105 pd=1.21 as=0.2325 ps=1.465 w=1 l=0.15
X4 a_27_47# A1 VGND VNB sky130_fd_pr__nfet_01v8 ad=0.169 pd=1.82 as=0.08775 ps=0.92 w=0.65 l=0.15
X5 Y B2 a_109_297# VPB sky130_fd_pr__pfet_01v8_hvt ad=0.2325 pd=1.465 as=0.1125 ps=1.225 w=1 l=0.15
X6 a_109_297# B1 VPWR VPB sky130_fd_pr__pfet_01v8_hvt ad=0.1125 pd=1.225 as=0.26 ps=2.52 w=1 l=0.15
X7 Y B1 a_27_47# VNB sky130_fd_pr__nfet_01v8 ad=0.092625 pd=0.935 as=0.169 ps=1.82 w=0.65 l=0.15
.ends

.subckt sky130_fd_sc_hd__dfxtp_1 Q CLK D VPB VNB VPWR VGND
X0 Q a_1059_315# VGND VNB sky130_fd_pr__nfet_01v8 ad=0.169 pd=1.82 as=0.08775 ps=0.92 w=0.65 l=0.15
X1 a_891_413# a_193_47# a_634_159# VNB sky130_fd_pr__nfet_01v8 ad=0.0684 pd=0.74 as=0.0989 ps=0.995 w=0.36 l=0.15
X2 a_561_413# a_27_47# a_466_413# VPB sky130_fd_pr__pfet_01v8_hvt ad=0.07665 pd=0.785 as=0.06825 ps=0.745 w=0.42 l=0.15
X3 VPWR CLK a_27_47# VPB sky130_fd_pr__pfet_01v8_hvt ad=0.0864 pd=0.91 as=0.1664 ps=1.8 w=0.64 l=0.15
X4 Q a_1059_315# VPWR VPB sky130_fd_pr__pfet_01v8_hvt ad=0.26 pd=2.52 as=0.135 ps=1.27 w=1 l=0.15
X5 a_381_47# D VPWR VPB sky130_fd_pr__pfet_01v8_hvt ad=0.05775 pd=0.695 as=0.1092 ps=1.36 w=0.42 l=0.15
X6 VGND a_634_159# a_592_47# VNB sky130_fd_pr__nfet_01v8 ad=0.12095 pd=1.085 as=0.0696 ps=0.765 w=0.42 l=0.15
X7 VPWR a_891_413# a_1059_315# VPB sky130_fd_pr__pfet_01v8_hvt ad=0.135 pd=1.27 as=0.27 ps=2.54 w=1 l=0.15
X8 a_466_413# a_193_47# a_381_47# VPB sky130_fd_pr__pfet_01v8_hvt ad=0.06825 pd=0.745 as=0.05775 ps=0.695 w=0.42 l=0.15
X9 VPWR a_634_159# a_561_413# VPB sky130_fd_pr__pfet_01v8_hvt ad=0.178875 pd=1.26 as=0.07665 ps=0.785 w=0.42 l=0.15
X10 a_634_159# a_466_413# VGND VNB sky130_fd_pr__nfet_01v8 ad=0.0989 pd=0.995 as=0.12095 ps=1.085 w=0.64 l=0.15
X11 a_634_159# a_466_413# VPWR VPB sky130_fd_pr__pfet_01v8_hvt ad=0.1095 pd=1.075 as=0.178875 ps=1.26 w=0.75 l=0.15
X12 a_975_413# a_193_47# a_891_413# VPB sky130_fd_pr__pfet_01v8_hvt ad=0.0882 pd=0.84 as=0.0567 ps=0.69 w=0.42 l=0.15
X13 VGND a_1059_315# a_1017_47# VNB sky130_fd_pr__nfet_01v8 ad=0.1092 pd=1.36 as=0.066 ps=0.745 w=0.42 l=0.15
X14 a_193_47# a_27_47# VGND VNB sky130_fd_pr__nfet_01v8 ad=0.1092 pd=1.36 as=0.0567 ps=0.69 w=0.42 l=0.15
X15 a_891_413# a_27_47# a_634_159# VPB sky130_fd_pr__pfet_01v8_hvt ad=0.0567 pd=0.69 as=0.1095 ps=1.075 w=0.42 l=0.15
X16 a_592_47# a_193_47# a_466_413# VNB sky130_fd_pr__nfet_01v8 ad=0.0696 pd=0.765 as=0.0621 ps=0.705 w=0.36 l=0.15
X17 a_1017_47# a_27_47# a_891_413# VNB sky130_fd_pr__nfet_01v8 ad=0.066 pd=0.745 as=0.0684 ps=0.74 w=0.36 l=0.15
X18 VPWR a_1059_315# a_975_413# VPB sky130_fd_pr__pfet_01v8_hvt ad=0.1113 pd=1.37 as=0.0882 ps=0.84 w=0.42 l=0.15
X19 a_466_413# a_27_47# a_381_47# VNB sky130_fd_pr__nfet_01v8 ad=0.0621 pd=0.705 as=0.0813 ps=0.83 w=0.36 l=0.15
X20 a_193_47# a_27_47# VPWR VPB sky130_fd_pr__pfet_01v8_hvt ad=0.1664 pd=1.8 as=0.0864 ps=0.91 w=0.64 l=0.15
X21 VGND a_891_413# a_1059_315# VNB sky130_fd_pr__nfet_01v8 ad=0.08775 pd=0.92 as=0.169 ps=1.82 w=0.65 l=0.15
X22 a_381_47# D VGND VNB sky130_fd_pr__nfet_01v8 ad=0.0813 pd=0.83 as=0.1092 ps=1.36 w=0.42 l=0.15
X23 VGND CLK a_27_47# VNB sky130_fd_pr__nfet_01v8 ad=0.0567 pd=0.69 as=0.1092 ps=1.36 w=0.42 l=0.15
.ends

.subckt sky130_fd_sc_hd__clkinv_1 VPB VNB VGND VPWR A Y
X0 Y A VPWR VPB sky130_fd_pr__pfet_01v8_hvt ad=0.1134 pd=1.11 as=0.2184 ps=2.2 w=0.84 l=0.15
X1 VGND A Y VNB sky130_fd_pr__nfet_01v8 ad=0.1197 pd=1.41 as=0.1092 ps=1.36 w=0.42 l=0.15
X2 VPWR A Y VPB sky130_fd_pr__pfet_01v8_hvt ad=0.2352 pd=2.24 as=0.1134 ps=1.11 w=0.84 l=0.15
.ends

.subckt sky130_fd_sc_hd__mux2_1 VGND VPWR VPB VNB X A1 S A0
X0 VPWR a_505_21# a_535_374# VPB sky130_fd_pr__pfet_01v8_hvt ad=0.0693 pd=0.75 as=0.0441 ps=0.63 w=0.42 l=0.15
X1 a_505_21# S VPWR VPB sky130_fd_pr__pfet_01v8_hvt ad=0.1176 pd=1.4 as=0.0693 ps=0.75 w=0.42 l=0.15
X2 a_218_374# S VPWR VPB sky130_fd_pr__pfet_01v8_hvt ad=0.07665 pd=0.785 as=0.15835 ps=1.395 w=0.42 l=0.15
X3 VGND a_505_21# a_439_47# VNB sky130_fd_pr__nfet_01v8 ad=0.1449 pd=1.11 as=0.0693 ps=0.75 w=0.42 l=0.15
X4 a_76_199# A0 a_218_374# VPB sky130_fd_pr__pfet_01v8_hvt ad=0.1932 pd=1.34 as=0.07665 ps=0.785 w=0.42 l=0.15
X5 a_505_21# S VGND VNB sky130_fd_pr__nfet_01v8 ad=0.1092 pd=1.36 as=0.1449 ps=1.11 w=0.42 l=0.15
X6 a_439_47# A0 a_76_199# VNB sky130_fd_pr__nfet_01v8 ad=0.0693 pd=0.75 as=0.09975 ps=0.895 w=0.42 l=0.15
X7 a_535_374# A1 a_76_199# VPB sky130_fd_pr__pfet_01v8_hvt ad=0.0441 pd=0.63 as=0.1932 ps=1.34 w=0.42 l=0.15
X8 a_76_199# A1 a_218_47# VNB sky130_fd_pr__nfet_01v8 ad=0.09975 pd=0.895 as=0.0693 ps=0.75 w=0.42 l=0.15
X9 a_218_47# S VGND VNB sky130_fd_pr__nfet_01v8 ad=0.0693 pd=0.75 as=0.11285 ps=1.045 w=0.42 l=0.15
X10 VPWR a_76_199# X VPB sky130_fd_pr__pfet_01v8_hvt ad=0.15835 pd=1.395 as=0.26 ps=2.52 w=1 l=0.15
X11 VGND a_76_199# X VNB sky130_fd_pr__nfet_01v8 ad=0.11285 pd=1.045 as=0.169 ps=1.82 w=0.65 l=0.15
.ends

.subckt sky130_fd_sc_hd__nor4_1 VPB VNB VGND VPWR Y D C B A
X0 Y B VGND VNB sky130_fd_pr__nfet_01v8 ad=0.08775 pd=0.92 as=0.089375 ps=0.925 w=0.65 l=0.15
X1 a_191_297# C a_109_297# VPB sky130_fd_pr__pfet_01v8_hvt ad=0.19 pd=1.38 as=0.13 ps=1.26 w=1 l=0.15
X2 VPWR A a_297_297# VPB sky130_fd_pr__pfet_01v8_hvt ad=0.26 pd=2.52 as=0.135 ps=1.27 w=1 l=0.15
X3 VGND C Y VNB sky130_fd_pr__nfet_01v8 ad=0.089375 pd=0.925 as=0.118625 ps=1.015 w=0.65 l=0.15
X4 VGND A Y VNB sky130_fd_pr__nfet_01v8 ad=0.169 pd=1.82 as=0.08775 ps=0.92 w=0.65 l=0.15
X5 a_297_297# B a_191_297# VPB sky130_fd_pr__pfet_01v8_hvt ad=0.135 pd=1.27 as=0.19 ps=1.38 w=1 l=0.15
X6 a_109_297# D Y VPB sky130_fd_pr__pfet_01v8_hvt ad=0.13 pd=1.26 as=0.26 ps=2.52 w=1 l=0.15
X7 Y D VGND VNB sky130_fd_pr__nfet_01v8 ad=0.118625 pd=1.015 as=0.169 ps=1.82 w=0.65 l=0.15
.ends

.subckt sky130_fd_sc_hd__clkbuf_8 X A VPB VNB VGND VPWR
X0 VPWR A a_110_47# VPB sky130_fd_pr__pfet_01v8_hvt ad=0.14 pd=1.28 as=0.14 ps=1.28 w=1 l=0.15
X1 VPWR a_110_47# X VPB sky130_fd_pr__pfet_01v8_hvt ad=0.14 pd=1.28 as=0.14 ps=1.28 w=1 l=0.15
X2 X a_110_47# VPWR VPB sky130_fd_pr__pfet_01v8_hvt ad=0.14 pd=1.28 as=0.14 ps=1.28 w=1 l=0.15
X3 a_110_47# A VPWR VPB sky130_fd_pr__pfet_01v8_hvt ad=0.14 pd=1.28 as=0.265 ps=2.53 w=1 l=0.15
X4 X a_110_47# VGND VNB sky130_fd_pr__nfet_01v8 ad=0.0588 pd=0.7 as=0.0588 ps=0.7 w=0.42 l=0.15
X5 X a_110_47# VPWR VPB sky130_fd_pr__pfet_01v8_hvt ad=0.14 pd=1.28 as=0.14 ps=1.28 w=1 l=0.15
X6 VGND a_110_47# X VNB sky130_fd_pr__nfet_01v8 ad=0.0588 pd=0.7 as=0.0588 ps=0.7 w=0.42 l=0.15
X7 VPWR a_110_47# X VPB sky130_fd_pr__pfet_01v8_hvt ad=0.14 pd=1.28 as=0.14 ps=1.28 w=1 l=0.15
X8 VGND A a_110_47# VNB sky130_fd_pr__nfet_01v8 ad=0.0588 pd=0.7 as=0.0588 ps=0.7 w=0.42 l=0.15
X9 VGND a_110_47# X VNB sky130_fd_pr__nfet_01v8 ad=0.1134 pd=1.38 as=0.0588 ps=0.7 w=0.42 l=0.15
X10 a_110_47# A VGND VNB sky130_fd_pr__nfet_01v8 ad=0.0588 pd=0.7 as=0.1113 ps=1.37 w=0.42 l=0.15
X11 VPWR a_110_47# X VPB sky130_fd_pr__pfet_01v8_hvt ad=0.14 pd=1.28 as=0.14 ps=1.28 w=1 l=0.15
X12 X a_110_47# VPWR VPB sky130_fd_pr__pfet_01v8_hvt ad=0.14 pd=1.28 as=0.14 ps=1.28 w=1 l=0.15
X13 VGND a_110_47# X VNB sky130_fd_pr__nfet_01v8 ad=0.0588 pd=0.7 as=0.0588 ps=0.7 w=0.42 l=0.15
X14 VGND a_110_47# X VNB sky130_fd_pr__nfet_01v8 ad=0.0588 pd=0.7 as=0.0588 ps=0.7 w=0.42 l=0.15
X15 X a_110_47# VPWR VPB sky130_fd_pr__pfet_01v8_hvt ad=0.14 pd=1.28 as=0.14 ps=1.28 w=1 l=0.15
X16 X a_110_47# VGND VNB sky130_fd_pr__nfet_01v8 ad=0.0588 pd=0.7 as=0.0588 ps=0.7 w=0.42 l=0.15
X17 VPWR a_110_47# X VPB sky130_fd_pr__pfet_01v8_hvt ad=0.265 pd=2.53 as=0.14 ps=1.28 w=1 l=0.15
X18 X a_110_47# VGND VNB sky130_fd_pr__nfet_01v8 ad=0.0588 pd=0.7 as=0.0588 ps=0.7 w=0.42 l=0.15
X19 X a_110_47# VGND VNB sky130_fd_pr__nfet_01v8 ad=0.0588 pd=0.7 as=0.0588 ps=0.7 w=0.42 l=0.15
.ends

.subckt sky130_fd_sc_hd__mux4_2 VNB VPB VGND VPWR S0 A2 A3 S1 A1 A0 X
X0 a_600_345# S1 VPWR VPB sky130_fd_pr__pfet_01v8_hvt ad=0.1664 pd=1.8 as=0.0864 ps=0.91 w=0.64 l=0.15
X1 a_788_316# S1 a_288_47# VNB sky130_fd_pr__nfet_01v8 ad=0.05775 pd=0.695 as=0.1092 ps=1.36 w=0.42 l=0.15
X2 VPWR A3 a_372_413# VPB sky130_fd_pr__pfet_01v8_hvt ad=0.0864 pd=0.91 as=0.1645 ps=1.33 w=0.64 l=0.15
X3 a_872_316# a_600_345# a_788_316# VNB sky130_fd_pr__nfet_01v8 ad=0.1092 pd=1.36 as=0.05775 ps=0.695 w=0.42 l=0.15
X4 VPWR S0 a_27_47# VPB sky130_fd_pr__pfet_01v8_hvt ad=0.0864 pd=0.91 as=0.1664 ps=1.8 w=0.64 l=0.15
X5 a_1279_413# S0 a_872_316# VPB sky130_fd_pr__pfet_01v8_hvt ad=0.10535 pd=0.995 as=0.0567 ps=0.69 w=0.42 l=0.15
X6 VGND a_788_316# X VNB sky130_fd_pr__nfet_01v8 ad=0.221 pd=1.98 as=0.08775 ps=0.92 w=0.65 l=0.15
X7 a_1060_369# A1 VPWR VPB sky130_fd_pr__pfet_01v8_hvt ad=0.13775 pd=1.165 as=0.1664 ps=1.8 w=0.64 l=0.15
X8 a_872_316# a_27_47# a_1060_369# VPB sky130_fd_pr__pfet_01v8_hvt ad=0.0567 pd=0.69 as=0.13775 ps=1.165 w=0.42 l=0.15
X9 a_1281_47# a_27_47# a_872_316# VNB sky130_fd_pr__nfet_01v8 ad=0.066 pd=0.745 as=0.072 ps=0.76 w=0.36 l=0.15
X10 a_193_47# A2 VGND VNB sky130_fd_pr__nfet_01v8 ad=0.066 pd=0.745 as=0.0567 ps=0.69 w=0.42 l=0.15
X11 a_1064_47# A1 VGND VNB sky130_fd_pr__nfet_01v8 ad=0.0786 pd=0.805 as=0.1092 ps=1.36 w=0.42 l=0.15
X12 a_872_316# S1 a_788_316# VPB sky130_fd_pr__pfet_01v8_hvt ad=0.1404 pd=1.6 as=0.0729 ps=0.81 w=0.54 l=0.15
X13 a_872_316# S0 a_1064_47# VNB sky130_fd_pr__nfet_01v8 ad=0.072 pd=0.76 as=0.0786 ps=0.805 w=0.36 l=0.15
X14 X a_788_316# VGND VNB sky130_fd_pr__nfet_01v8 ad=0.08775 pd=0.92 as=0.10675 ps=1.005 w=0.65 l=0.15
X15 a_788_316# a_600_345# a_288_47# VPB sky130_fd_pr__pfet_01v8_hvt ad=0.0729 pd=0.81 as=0.1404 ps=1.6 w=0.54 l=0.15
X16 a_372_413# a_27_47# a_288_47# VPB sky130_fd_pr__pfet_01v8_hvt ad=0.1645 pd=1.33 as=0.0567 ps=0.69 w=0.42 l=0.15
X17 VGND A3 a_397_47# VNB sky130_fd_pr__nfet_01v8 ad=0.0819 pd=0.81 as=0.06705 ps=0.75 w=0.42 l=0.15
X18 a_600_345# S1 VGND VNB sky130_fd_pr__nfet_01v8 ad=0.1134 pd=1.38 as=0.0819 ps=0.81 w=0.42 l=0.15
X19 a_193_369# A2 VPWR VPB sky130_fd_pr__pfet_01v8_hvt ad=0.09575 pd=0.965 as=0.0864 ps=0.91 w=0.64 l=0.15
X20 VPWR a_788_316# X VPB sky130_fd_pr__pfet_01v8_hvt ad=0.34 pd=2.68 as=0.135 ps=1.27 w=1 l=0.15
X21 a_288_47# S0 a_193_369# VPB sky130_fd_pr__pfet_01v8_hvt ad=0.0567 pd=0.69 as=0.09575 ps=0.965 w=0.42 l=0.15
X22 a_397_47# S0 a_288_47# VNB sky130_fd_pr__nfet_01v8 ad=0.06705 pd=0.75 as=0.0711 ps=0.755 w=0.36 l=0.15
X23 VGND A0 a_1281_47# VNB sky130_fd_pr__nfet_01v8 ad=0.10675 pd=1.005 as=0.066 ps=0.745 w=0.42 l=0.15
X24 a_288_47# a_27_47# a_193_47# VNB sky130_fd_pr__nfet_01v8 ad=0.0711 pd=0.755 as=0.066 ps=0.745 w=0.36 l=0.15
X25 X a_788_316# VPWR VPB sky130_fd_pr__pfet_01v8_hvt ad=0.135 pd=1.27 as=0.154 ps=1.335 w=1 l=0.15
X26 VGND S0 a_27_47# VNB sky130_fd_pr__nfet_01v8 ad=0.0567 pd=0.69 as=0.1092 ps=1.36 w=0.42 l=0.15
X27 VPWR A0 a_1279_413# VPB sky130_fd_pr__pfet_01v8_hvt ad=0.154 pd=1.335 as=0.10535 ps=0.995 w=0.64 l=0.15
.ends

.subckt sky130_fd_sc_hd__nor3b_1 VPB VNB VGND VPWR C_N B Y A
X0 VGND a_91_199# Y VNB sky130_fd_pr__nfet_01v8 ad=0.08775 pd=0.92 as=0.221 ps=1.98 w=0.65 l=0.15
X1 Y B VGND VNB sky130_fd_pr__nfet_01v8 ad=0.08775 pd=0.92 as=0.08775 ps=0.92 w=0.65 l=0.15
X2 VPWR A a_245_297# VPB sky130_fd_pr__pfet_01v8_hvt ad=0.14575 pd=1.335 as=0.135 ps=1.27 w=1 l=0.15
X3 a_91_199# C_N VGND VNB sky130_fd_pr__nfet_01v8 ad=0.1092 pd=1.36 as=0.10025 ps=0.985 w=0.42 l=0.15
X4 VGND A Y VNB sky130_fd_pr__nfet_01v8 ad=0.10025 pd=0.985 as=0.08775 ps=0.92 w=0.65 l=0.15
X5 a_245_297# B a_161_297# VPB sky130_fd_pr__pfet_01v8_hvt ad=0.135 pd=1.27 as=0.135 ps=1.27 w=1 l=0.15
X6 a_91_199# C_N VPWR VPB sky130_fd_pr__pfet_01v8_hvt ad=0.1092 pd=1.36 as=0.14575 ps=1.335 w=0.42 l=0.15
X7 a_161_297# a_91_199# Y VPB sky130_fd_pr__pfet_01v8_hvt ad=0.135 pd=1.27 as=0.32 ps=2.64 w=1 l=0.15
.ends

.subckt sky130_fd_sc_hd__nand3b_1 VPB VNB VGND VPWR Y B C A_N
X0 Y a_53_93# VPWR VPB sky130_fd_pr__pfet_01v8_hvt ad=0.28 pd=2.56 as=0.1925 ps=1.385 w=1 l=0.15
X1 a_232_47# C VGND VNB sky130_fd_pr__nfet_01v8 ad=0.08775 pd=0.92 as=0.10025 ps=0.985 w=0.65 l=0.15
X2 VPWR B Y VPB sky130_fd_pr__pfet_01v8_hvt ad=0.1925 pd=1.385 as=0.135 ps=1.27 w=1 l=0.15
X3 VPWR A_N a_53_93# VPB sky130_fd_pr__pfet_01v8_hvt ad=0.14575 pd=1.335 as=0.1092 ps=1.36 w=0.42 l=0.15
X4 VGND A_N a_53_93# VNB sky130_fd_pr__nfet_01v8 ad=0.10025 pd=0.985 as=0.1092 ps=1.36 w=0.42 l=0.15
X5 a_316_47# B a_232_47# VNB sky130_fd_pr__nfet_01v8 ad=0.125125 pd=1.035 as=0.08775 ps=0.92 w=0.65 l=0.15
X6 Y a_53_93# a_316_47# VNB sky130_fd_pr__nfet_01v8 ad=0.182 pd=1.86 as=0.125125 ps=1.035 w=0.65 l=0.15
X7 Y C VPWR VPB sky130_fd_pr__pfet_01v8_hvt ad=0.135 pd=1.27 as=0.14575 ps=1.335 w=1 l=0.15
.ends

.subckt sky130_fd_sc_hd__xnor3_1 VNB VPB VGND VPWR X C B A
X0 a_841_297# a_735_297# a_355_49# VNB sky130_fd_pr__nfet_01v8 ad=0.11 pd=0.99 as=0.140825 ps=1.1 w=0.6 l=0.15
X1 a_1106_49# a_841_297# VGND VNB sky130_fd_pr__nfet_01v8 ad=0.1824 pd=1.85 as=0.0864 ps=0.91 w=0.64 l=0.15
X2 a_78_199# C a_355_49# VNB sky130_fd_pr__nfet_01v8 ad=0.0928 pd=0.93 as=0.1728 ps=1.82 w=0.64 l=0.15
X3 a_1106_49# a_735_297# a_355_49# VPB sky130_fd_pr__pfet_01v8_hvt ad=0.246 pd=1.525 as=0.2431 ps=1.445 w=0.64 l=0.15
X4 a_735_297# B VGND VNB sky130_fd_pr__nfet_01v8 ad=0.16515 pd=1.82 as=0.1885 ps=1.88 w=0.65 l=0.15
X5 a_1106_49# a_841_297# VPWR VPB sky130_fd_pr__pfet_01v8_hvt ad=0.285 pd=2.57 as=0.135 ps=1.27 w=1 l=0.15
X6 VPWR A a_841_297# VPB sky130_fd_pr__pfet_01v8_hvt ad=0.135 pd=1.27 as=0.1715 ps=1.355 w=1 l=0.15
X7 a_331_325# B a_841_297# VNB sky130_fd_pr__nfet_01v8 ad=0.18205 pd=1.245 as=0.16275 ps=1.8 w=0.64 l=0.15
X8 a_355_49# B a_841_297# VPB sky130_fd_pr__pfet_01v8_hvt ad=0.2431 pd=1.445 as=0.3528 ps=2.52 w=0.84 l=0.15
X9 a_216_93# C VPWR VPB sky130_fd_pr__pfet_01v8_hvt ad=0.1792 pd=1.84 as=0.169 ps=1.365 w=0.64 l=0.15
X10 a_735_297# B VPWR VPB sky130_fd_pr__pfet_01v8_hvt ad=0.26 pd=2.52 as=0.25655 ps=2.52 w=1 l=0.15
X11 VPWR a_78_199# X VPB sky130_fd_pr__pfet_01v8_hvt ad=0.169 pd=1.365 as=0.28 ps=2.56 w=1 l=0.15
X12 a_355_49# B a_1106_49# VNB sky130_fd_pr__nfet_01v8 ad=0.140825 pd=1.1 as=0.19265 ps=1.285 w=0.64 l=0.15
X13 a_331_325# B a_1106_49# VPB sky130_fd_pr__pfet_01v8_hvt ad=0.1458 pd=1.205 as=0.246 ps=1.525 w=0.64 l=0.15
X14 a_331_325# a_216_93# a_78_199# VNB sky130_fd_pr__nfet_01v8 ad=0.224 pd=1.98 as=0.0928 ps=0.93 w=0.64 l=0.15
X15 a_78_199# C a_331_325# VPB sky130_fd_pr__pfet_01v8_hvt ad=0.15295 pd=1.315 as=0.273 ps=2.33 w=0.84 l=0.15
X16 a_355_49# a_216_93# a_78_199# VPB sky130_fd_pr__pfet_01v8_hvt ad=0.32235 pd=2.45 as=0.15295 ps=1.315 w=0.84 l=0.15
X17 VGND A a_841_297# VNB sky130_fd_pr__nfet_01v8 ad=0.0864 pd=0.91 as=0.11 ps=0.99 w=0.64 l=0.15
X18 a_216_93# C VGND VNB sky130_fd_pr__nfet_01v8 ad=0.1785 pd=1.69 as=0.1165 ps=1.035 w=0.42 l=0.15
X19 a_1106_49# a_735_297# a_331_325# VNB sky130_fd_pr__nfet_01v8 ad=0.19265 pd=1.285 as=0.18205 ps=1.245 w=0.42 l=0.15
X20 a_841_297# a_735_297# a_331_325# VPB sky130_fd_pr__pfet_01v8_hvt ad=0.1715 pd=1.355 as=0.1458 ps=1.205 w=0.84 l=0.15
X21 VGND a_78_199# X VNB sky130_fd_pr__nfet_01v8 ad=0.1165 pd=1.035 as=0.169 ps=1.82 w=0.65 l=0.15
.ends

.subckt sky130_fd_sc_hd__a21oi_1 VPWR VGND VPB VNB A2 A1 B1 Y
X0 a_199_47# A1 Y VNB sky130_fd_pr__nfet_01v8 ad=0.095875 pd=0.945 as=0.091 ps=0.93 w=0.65 l=0.15
X1 a_113_297# A2 VPWR VPB sky130_fd_pr__pfet_01v8_hvt ad=0.265 pd=2.53 as=0.1475 ps=1.295 w=1 l=0.15
X2 Y B1 VGND VNB sky130_fd_pr__nfet_01v8 ad=0.091 pd=0.93 as=0.17225 ps=1.83 w=0.65 l=0.15
X3 VPWR A1 a_113_297# VPB sky130_fd_pr__pfet_01v8_hvt ad=0.1475 pd=1.295 as=0.14 ps=1.28 w=1 l=0.15
X4 a_113_297# B1 Y VPB sky130_fd_pr__pfet_01v8_hvt ad=0.14 pd=1.28 as=0.265 ps=2.53 w=1 l=0.15
X5 VGND A2 a_199_47# VNB sky130_fd_pr__nfet_01v8 ad=0.17225 pd=1.83 as=0.095875 ps=0.945 w=0.65 l=0.15
.ends

.subckt sky130_fd_sc_hd__xnor2_1 VGND VPWR B Y A VPB VNB
X0 a_377_297# A VPWR VPB sky130_fd_pr__pfet_01v8_hvt ad=0.105 pd=1.21 as=0.365 ps=1.73 w=1 l=0.15
X1 a_47_47# B VPWR VPB sky130_fd_pr__pfet_01v8_hvt ad=0.135 pd=1.27 as=0.3 ps=2.6 w=1 l=0.15
X2 a_129_47# B a_47_47# VNB sky130_fd_pr__nfet_01v8 ad=0.06825 pd=0.86 as=0.169 ps=1.82 w=0.65 l=0.15
X3 a_285_47# B VGND VNB sky130_fd_pr__nfet_01v8 ad=0.08775 pd=0.92 as=0.169 ps=1.82 w=0.65 l=0.15
X4 Y a_47_47# a_285_47# VNB sky130_fd_pr__nfet_01v8 ad=0.195 pd=1.9 as=0.08775 ps=0.92 w=0.65 l=0.15
X5 VGND A a_129_47# VNB sky130_fd_pr__nfet_01v8 ad=0.08775 pd=0.92 as=0.06825 ps=0.86 w=0.65 l=0.15
X6 VPWR A a_47_47# VPB sky130_fd_pr__pfet_01v8_hvt ad=0.365 pd=1.73 as=0.135 ps=1.27 w=1 l=0.15
X7 VPWR a_47_47# Y VPB sky130_fd_pr__pfet_01v8_hvt ad=0.36 pd=2.72 as=0.165 ps=1.33 w=1 l=0.15
X8 Y B a_377_297# VPB sky130_fd_pr__pfet_01v8_hvt ad=0.165 pd=1.33 as=0.105 ps=1.21 w=1 l=0.15
X9 a_285_47# A VGND VNB sky130_fd_pr__nfet_01v8 ad=0.169 pd=1.82 as=0.08775 ps=0.92 w=0.65 l=0.15
.ends

.subckt sky130_fd_sc_hd__nand2_1 VPB VNB VGND VPWR A Y B
X0 VPWR A Y VPB sky130_fd_pr__pfet_01v8_hvt ad=0.26 pd=2.52 as=0.135 ps=1.27 w=1 l=0.15
X1 Y A a_113_47# VNB sky130_fd_pr__nfet_01v8 ad=0.169 pd=1.82 as=0.08775 ps=0.92 w=0.65 l=0.15
X2 a_113_47# B VGND VNB sky130_fd_pr__nfet_01v8 ad=0.08775 pd=0.92 as=0.169 ps=1.82 w=0.65 l=0.15
X3 Y B VPWR VPB sky130_fd_pr__pfet_01v8_hvt ad=0.135 pd=1.27 as=0.26 ps=2.52 w=1 l=0.15
.ends

.subckt sky130_fd_sc_hd__nand4_1 VPB VNB VPWR VGND A C D Y B
X0 Y B VPWR VPB sky130_fd_pr__pfet_01v8_hvt ad=0.165 pd=1.33 as=0.135 ps=1.27 w=1 l=0.15
X1 VPWR A Y VPB sky130_fd_pr__pfet_01v8_hvt ad=0.3 pd=2.6 as=0.165 ps=1.33 w=1 l=0.15
X2 VPWR C Y VPB sky130_fd_pr__pfet_01v8_hvt ad=0.135 pd=1.27 as=0.135 ps=1.27 w=1 l=0.15
X3 a_193_47# C a_109_47# VNB sky130_fd_pr__nfet_01v8 ad=0.08775 pd=0.92 as=0.08775 ps=0.92 w=0.65 l=0.15
X4 Y A a_277_47# VNB sky130_fd_pr__nfet_01v8 ad=0.195 pd=1.9 as=0.10725 ps=0.98 w=0.65 l=0.15
X5 a_277_47# B a_193_47# VNB sky130_fd_pr__nfet_01v8 ad=0.10725 pd=0.98 as=0.08775 ps=0.92 w=0.65 l=0.15
X6 Y D VPWR VPB sky130_fd_pr__pfet_01v8_hvt ad=0.135 pd=1.27 as=0.26 ps=2.52 w=1 l=0.15
X7 a_109_47# D VGND VNB sky130_fd_pr__nfet_01v8 ad=0.08775 pd=0.92 as=0.169 ps=1.82 w=0.65 l=0.15
.ends

.subckt sky130_fd_sc_hd__nand2b_1 VPB VNB VGND VPWR A_N B Y
X0 VGND A_N a_27_93# VNB sky130_fd_pr__nfet_01v8 ad=0.10025 pd=0.985 as=0.1092 ps=1.36 w=0.42 l=0.15
X1 Y a_27_93# a_206_47# VNB sky130_fd_pr__nfet_01v8 ad=0.169 pd=1.82 as=0.08775 ps=0.92 w=0.65 l=0.15
X2 a_206_47# B VGND VNB sky130_fd_pr__nfet_01v8 ad=0.08775 pd=0.92 as=0.10025 ps=0.985 w=0.65 l=0.15
X3 VPWR a_27_93# Y VPB sky130_fd_pr__pfet_01v8_hvt ad=0.265 pd=2.53 as=0.135 ps=1.27 w=1 l=0.15
X4 Y B VPWR VPB sky130_fd_pr__pfet_01v8_hvt ad=0.135 pd=1.27 as=0.14575 ps=1.335 w=1 l=0.15
X5 VPWR A_N a_27_93# VPB sky130_fd_pr__pfet_01v8_hvt ad=0.14575 pd=1.335 as=0.1092 ps=1.36 w=0.42 l=0.15
.ends

.subckt sky130_fd_sc_hd__xor2_1 VNB VPB VPWR VGND A X B
X0 X a_35_297# a_285_297# VPB sky130_fd_pr__pfet_01v8_hvt ad=0.3 pd=2.6 as=0.26 ps=2.52 w=1 l=0.15
X1 X B a_285_47# VNB sky130_fd_pr__nfet_01v8 ad=0.25025 pd=1.42 as=0.08775 ps=0.92 w=0.65 l=0.15
X2 a_35_297# B VGND VNB sky130_fd_pr__nfet_01v8 ad=0.08775 pd=0.92 as=0.169 ps=1.82 w=0.65 l=0.15
X3 a_117_297# B a_35_297# VPB sky130_fd_pr__pfet_01v8_hvt ad=0.135 pd=1.27 as=0.26 ps=2.52 w=1 l=0.15
X4 VPWR B a_285_297# VPB sky130_fd_pr__pfet_01v8_hvt ad=0.26 pd=2.52 as=0.135 ps=1.27 w=1 l=0.15
X5 VGND A a_35_297# VNB sky130_fd_pr__nfet_01v8 ad=0.08775 pd=0.92 as=0.08775 ps=0.92 w=0.65 l=0.15
X6 VGND a_35_297# X VNB sky130_fd_pr__nfet_01v8 ad=0.208 pd=1.94 as=0.25025 ps=1.42 w=0.65 l=0.15
X7 a_285_297# A VPWR VPB sky130_fd_pr__pfet_01v8_hvt ad=0.135 pd=1.27 as=0.135 ps=1.27 w=1 l=0.15
X8 VPWR A a_117_297# VPB sky130_fd_pr__pfet_01v8_hvt ad=0.135 pd=1.27 as=0.135 ps=1.27 w=1 l=0.15
X9 a_285_47# A VGND VNB sky130_fd_pr__nfet_01v8 ad=0.08775 pd=0.92 as=0.08775 ps=0.92 w=0.65 l=0.15
.ends

.subckt sky130_fd_sc_hd__and3_1 VGND VPWR X B A C VPB VNB
X0 VPWR A a_27_47# VPB sky130_fd_pr__pfet_01v8_hvt ad=0.0567 pd=0.69 as=0.1092 ps=1.36 w=0.42 l=0.15
X1 VPWR C a_27_47# VPB sky130_fd_pr__pfet_01v8_hvt ad=0.142225 pd=1.335 as=0.06615 ps=0.735 w=0.42 l=0.15
X2 a_181_47# B a_109_47# VNB sky130_fd_pr__nfet_01v8 ad=0.0441 pd=0.63 as=0.0441 ps=0.63 w=0.42 l=0.15
X3 VGND C a_181_47# VNB sky130_fd_pr__nfet_01v8 ad=0.13165 pd=1.14 as=0.0441 ps=0.63 w=0.42 l=0.15
X4 a_27_47# B VPWR VPB sky130_fd_pr__pfet_01v8_hvt ad=0.06615 pd=0.735 as=0.0567 ps=0.69 w=0.42 l=0.15
X5 X a_27_47# VPWR VPB sky130_fd_pr__pfet_01v8_hvt ad=0.26 pd=2.52 as=0.142225 ps=1.335 w=1 l=0.15
X6 X a_27_47# VGND VNB sky130_fd_pr__nfet_01v8 ad=0.169 pd=1.82 as=0.13165 ps=1.14 w=0.65 l=0.15
X7 a_109_47# A a_27_47# VNB sky130_fd_pr__nfet_01v8 ad=0.0441 pd=0.63 as=0.1092 ps=1.36 w=0.42 l=0.15
.ends

.subckt sky130_fd_sc_hd__a31oi_1 VGND VPWR VPB VNB A3 A2 A1 Y B1
X0 Y A1 a_181_47# VNB sky130_fd_pr__nfet_01v8 ad=0.105625 pd=0.975 as=0.118625 ps=1.015 w=0.65 l=0.15
X1 a_181_47# A2 a_109_47# VNB sky130_fd_pr__nfet_01v8 ad=0.118625 pd=1.015 as=0.06825 ps=0.86 w=0.65 l=0.15
X2 VGND B1 Y VNB sky130_fd_pr__nfet_01v8 ad=0.1755 pd=1.84 as=0.105625 ps=0.975 w=0.65 l=0.15
X3 VPWR A2 a_109_297# VPB sky130_fd_pr__pfet_01v8_hvt ad=0.1525 pd=1.305 as=0.135 ps=1.27 w=1 l=0.15
X4 Y B1 a_109_297# VPB sky130_fd_pr__pfet_01v8_hvt ad=0.27 pd=2.54 as=0.1625 ps=1.325 w=1 l=0.15
X5 a_109_297# A1 VPWR VPB sky130_fd_pr__pfet_01v8_hvt ad=0.1625 pd=1.325 as=0.1525 ps=1.305 w=1 l=0.15
X6 a_109_297# A3 VPWR VPB sky130_fd_pr__pfet_01v8_hvt ad=0.135 pd=1.27 as=0.26 ps=2.52 w=1 l=0.15
X7 a_109_47# A3 VGND VNB sky130_fd_pr__nfet_01v8 ad=0.06825 pd=0.86 as=0.169 ps=1.82 w=0.65 l=0.15
.ends

.subckt sky130_fd_sc_hd__and4b_1 VGND VPWR C A_N X D B VPB VNB
X0 a_297_47# a_27_47# a_193_413# VNB sky130_fd_pr__nfet_01v8 ad=0.0441 pd=0.63 as=0.1092 ps=1.36 w=0.42 l=0.15
X1 a_369_47# B a_297_47# VNB sky130_fd_pr__nfet_01v8 ad=0.0735 pd=0.77 as=0.0441 ps=0.63 w=0.42 l=0.15
X2 VPWR D a_193_413# VPB sky130_fd_pr__pfet_01v8_hvt ad=0.14075 pd=1.325 as=0.06615 ps=0.735 w=0.42 l=0.15
X3 X a_193_413# VGND VNB sky130_fd_pr__nfet_01v8 ad=0.169 pd=1.82 as=0.1034 ps=1 w=0.65 l=0.15
X4 VPWR A_N a_27_47# VPB sky130_fd_pr__pfet_01v8_hvt ad=0.0567 pd=0.69 as=0.1092 ps=1.36 w=0.42 l=0.15
X5 VGND D a_469_47# VNB sky130_fd_pr__nfet_01v8 ad=0.1034 pd=1 as=0.0609 ps=0.71 w=0.42 l=0.15
X6 X a_193_413# VPWR VPB sky130_fd_pr__pfet_01v8_hvt ad=0.26 pd=2.52 as=0.14075 ps=1.325 w=1 l=0.15
X7 VPWR B a_193_413# VPB sky130_fd_pr__pfet_01v8_hvt ad=0.1281 pd=1.03 as=0.0987 ps=0.89 w=0.42 l=0.15
X8 a_193_413# C VPWR VPB sky130_fd_pr__pfet_01v8_hvt ad=0.06615 pd=0.735 as=0.1281 ps=1.03 w=0.42 l=0.15
X9 a_193_413# a_27_47# VPWR VPB sky130_fd_pr__pfet_01v8_hvt ad=0.0987 pd=0.89 as=0.0567 ps=0.69 w=0.42 l=0.15
X10 a_469_47# C a_369_47# VNB sky130_fd_pr__nfet_01v8 ad=0.0609 pd=0.71 as=0.0735 ps=0.77 w=0.42 l=0.15
X11 VGND A_N a_27_47# VNB sky130_fd_pr__nfet_01v8 ad=0.1092 pd=1.36 as=0.1092 ps=1.36 w=0.42 l=0.15
.ends

.subckt sky130_fd_sc_hd__a22oi_1 VPWR VGND VPB VNB B2 B1 Y A1 A2
X0 Y B1 a_109_47# VNB sky130_fd_pr__nfet_01v8 ad=0.169 pd=1.82 as=0.07475 ps=0.88 w=0.65 l=0.15
X1 Y B1 a_109_297# VPB sky130_fd_pr__pfet_01v8_hvt ad=0.26 pd=2.52 as=0.135 ps=1.27 w=1 l=0.15
X2 VPWR A2 a_109_297# VPB sky130_fd_pr__pfet_01v8_hvt ad=0.3 pd=2.6 as=0.135 ps=1.27 w=1 l=0.15
X3 a_109_297# A1 VPWR VPB sky130_fd_pr__pfet_01v8_hvt ad=0.135 pd=1.27 as=0.26 ps=2.52 w=1 l=0.15
X4 a_381_47# A1 Y VNB sky130_fd_pr__nfet_01v8 ad=0.06825 pd=0.86 as=0.169 ps=1.82 w=0.65 l=0.15
X5 a_109_297# B2 Y VPB sky130_fd_pr__pfet_01v8_hvt ad=0.135 pd=1.27 as=0.26 ps=2.52 w=1 l=0.15
X6 a_109_47# B2 VGND VNB sky130_fd_pr__nfet_01v8 ad=0.07475 pd=0.88 as=0.169 ps=1.82 w=0.65 l=0.15
X7 VGND A2 a_381_47# VNB sky130_fd_pr__nfet_01v8 ad=0.234 pd=2.02 as=0.06825 ps=0.86 w=0.65 l=0.15
.ends

.subckt sky130_fd_sc_hd__a221oi_1 VGND VPWR VPB VNB Y B1 C1 A1 A2 B2
X0 a_465_47# A1 Y VNB sky130_fd_pr__nfet_01v8 ad=0.099125 pd=0.955 as=0.169 ps=1.82 w=0.65 l=0.15
X1 a_109_297# B1 a_193_297# VPB sky130_fd_pr__pfet_01v8_hvt ad=0.26 pd=2.52 as=0.135 ps=1.27 w=1 l=0.15
X2 a_193_297# B2 a_109_297# VPB sky130_fd_pr__pfet_01v8_hvt ad=0.135 pd=1.27 as=0.135 ps=1.27 w=1 l=0.15
X3 a_204_47# B2 VGND VNB sky130_fd_pr__nfet_01v8 ad=0.069875 pd=0.865 as=0.105625 ps=0.975 w=0.65 l=0.15
X4 VGND A2 a_465_47# VNB sky130_fd_pr__nfet_01v8 ad=0.19825 pd=1.91 as=0.099125 ps=0.955 w=0.65 l=0.15
X5 a_193_297# A1 VPWR VPB sky130_fd_pr__pfet_01v8_hvt ad=0.1525 pd=1.305 as=0.26 ps=2.52 w=1 l=0.15
X6 Y B1 a_204_47# VNB sky130_fd_pr__nfet_01v8 ad=0.169 pd=1.82 as=0.069875 ps=0.865 w=0.65 l=0.15
X7 VPWR A2 a_193_297# VPB sky130_fd_pr__pfet_01v8_hvt ad=0.305 pd=2.61 as=0.1525 ps=1.305 w=1 l=0.15
X8 a_109_297# C1 Y VPB sky130_fd_pr__pfet_01v8_hvt ad=0.135 pd=1.27 as=0.26 ps=2.52 w=1 l=0.15
X9 VGND C1 Y VNB sky130_fd_pr__nfet_01v8 ad=0.105625 pd=0.975 as=0.169 ps=1.82 w=0.65 l=0.15
.ends

.subckt sky130_fd_sc_hd__lpflow_isobufsrc_1 VPB VNB VGND VPWR A SLEEP X
X0 X a_74_47# a_265_297# VPB sky130_fd_pr__pfet_01v8_hvt ad=0.26 pd=2.52 as=0.105 ps=1.21 w=1 l=0.15
X1 VPWR A a_74_47# VPB sky130_fd_pr__pfet_01v8_hvt ad=0.1573 pd=1.39 as=0.1092 ps=1.36 w=0.42 l=0.15
X2 a_265_297# SLEEP VPWR VPB sky130_fd_pr__pfet_01v8_hvt ad=0.105 pd=1.21 as=0.1573 ps=1.39 w=1 l=0.15
X3 X SLEEP VGND VNB sky130_fd_pr__nfet_01v8 ad=0.08775 pd=0.92 as=0.10025 ps=0.985 w=0.65 l=0.15
X4 VGND A a_74_47# VNB sky130_fd_pr__nfet_01v8 ad=0.10025 pd=0.985 as=0.1092 ps=1.36 w=0.42 l=0.15
X5 VGND a_74_47# X VNB sky130_fd_pr__nfet_01v8 ad=0.169 pd=1.82 as=0.08775 ps=0.92 w=0.65 l=0.15
.ends

.subckt sky130_fd_sc_hd__dfstp_2 VPB VNB VPWR VGND Q SET_B D CLK
X0 VGND a_652_21# a_586_47# VNB sky130_fd_pr__nfet_01v8 ad=0.0882 pd=0.84 as=0.06705 ps=0.75 w=0.42 l=0.15
X1 a_956_413# a_476_47# VPWR VPB sky130_fd_pr__pfet_01v8_hvt ad=0.0441 pd=0.63 as=0.0567 ps=0.69 w=0.42 l=0.15
X2 a_1136_413# a_193_47# a_1028_413# VPB sky130_fd_pr__pfet_01v8_hvt ad=0.0441 pd=0.63 as=0.0819 ps=0.81 w=0.42 l=0.15
X3 VPWR a_476_47# a_652_21# VPB sky130_fd_pr__pfet_01v8_hvt ad=0.0567 pd=0.69 as=0.0567 ps=0.69 w=0.42 l=0.15
X4 a_586_47# a_193_47# a_476_47# VNB sky130_fd_pr__nfet_01v8 ad=0.06705 pd=0.75 as=0.072 ps=0.76 w=0.36 l=0.15
X5 a_1228_47# a_27_47# a_1028_413# VNB sky130_fd_pr__nfet_01v8 ad=0.0441 pd=0.63 as=0.0735 ps=0.77 w=0.42 l=0.15
X6 VPWR CLK a_27_47# VPB sky130_fd_pr__pfet_01v8_hvt ad=0.0864 pd=0.91 as=0.1664 ps=1.8 w=0.64 l=0.15
X7 a_476_47# a_27_47# a_381_47# VNB sky130_fd_pr__nfet_01v8 ad=0.072 pd=0.76 as=0.0935 ps=0.965 w=0.36 l=0.15
X8 a_1056_47# a_476_47# VGND VNB sky130_fd_pr__nfet_01v8 ad=0.0441 pd=0.63 as=0.1092 ps=1.36 w=0.42 l=0.15
X9 a_381_47# D VPWR VPB sky130_fd_pr__pfet_01v8_hvt ad=0.12495 pd=1.175 as=0.2184 ps=2.2 w=0.84 l=0.15
X10 a_652_21# SET_B VPWR VPB sky130_fd_pr__pfet_01v8_hvt ad=0.0567 pd=0.69 as=0.0798 ps=0.8 w=0.42 l=0.15
X11 VPWR a_1602_47# Q VPB sky130_fd_pr__pfet_01v8_hvt ad=0.26 pd=2.52 as=0.135 ps=1.27 w=1 l=0.15
X12 a_562_413# a_27_47# a_476_47# VPB sky130_fd_pr__pfet_01v8_hvt ad=0.0945 pd=0.87 as=0.0567 ps=0.69 w=0.42 l=0.15
X13 VGND a_1028_413# a_1602_47# VNB sky130_fd_pr__nfet_01v8 ad=0.08775 pd=0.92 as=0.169 ps=1.82 w=0.65 l=0.15
X14 VGND a_1602_47# Q VNB sky130_fd_pr__nfet_01v8 ad=0.169 pd=1.82 as=0.08775 ps=0.92 w=0.65 l=0.15
X15 Q a_1602_47# VPWR VPB sky130_fd_pr__pfet_01v8_hvt ad=0.135 pd=1.27 as=0.135 ps=1.27 w=1 l=0.15
X16 a_1028_413# a_193_47# a_1056_47# VNB sky130_fd_pr__nfet_01v8 ad=0.0735 pd=0.77 as=0.0441 ps=0.63 w=0.42 l=0.15
X17 a_476_47# a_193_47# a_381_47# VPB sky130_fd_pr__pfet_01v8_hvt ad=0.0567 pd=0.69 as=0.12495 ps=1.175 w=0.42 l=0.15
X18 a_193_47# a_27_47# VGND VNB sky130_fd_pr__nfet_01v8 ad=0.1092 pd=1.36 as=0.0567 ps=0.69 w=0.42 l=0.15
X19 VPWR a_1028_413# a_1602_47# VPB sky130_fd_pr__pfet_01v8_hvt ad=0.135 pd=1.27 as=0.26 ps=2.52 w=1 l=0.15
X20 VPWR a_652_21# a_562_413# VPB sky130_fd_pr__pfet_01v8_hvt ad=0.0798 pd=0.8 as=0.0945 ps=0.87 w=0.42 l=0.15
X21 Q a_1602_47# VGND VNB sky130_fd_pr__nfet_01v8 ad=0.08775 pd=0.92 as=0.08775 ps=0.92 w=0.65 l=0.15
X22 a_1028_413# a_27_47# a_956_413# VPB sky130_fd_pr__pfet_01v8_hvt ad=0.0819 pd=0.81 as=0.0441 ps=0.63 w=0.42 l=0.15
X23 VPWR a_1178_261# a_1136_413# VPB sky130_fd_pr__pfet_01v8_hvt ad=0.1092 pd=1.36 as=0.0441 ps=0.63 w=0.42 l=0.15
X24 a_193_47# a_27_47# VPWR VPB sky130_fd_pr__pfet_01v8_hvt ad=0.1664 pd=1.8 as=0.0864 ps=0.91 w=0.64 l=0.15
X25 a_1178_261# a_1028_413# VPWR VPB sky130_fd_pr__pfet_01v8_hvt ad=0.2226 pd=2.21 as=0.12075 ps=1.165 w=0.84 l=0.15
X26 a_796_47# SET_B VGND VNB sky130_fd_pr__nfet_01v8 ad=0.0441 pd=0.63 as=0.0882 ps=0.84 w=0.42 l=0.15
X27 a_1300_47# a_1178_261# a_1228_47# VNB sky130_fd_pr__nfet_01v8 ad=0.0441 pd=0.63 as=0.0441 ps=0.63 w=0.42 l=0.15
X28 a_381_47# D VGND VNB sky130_fd_pr__nfet_01v8 ad=0.0935 pd=0.965 as=0.1664 ps=1.8 w=0.64 l=0.15
X29 a_1178_261# a_1028_413# VGND VNB sky130_fd_pr__nfet_01v8 ad=0.1404 pd=1.6 as=0.1137 ps=1.01 w=0.54 l=0.15
X30 a_652_21# a_476_47# a_796_47# VNB sky130_fd_pr__nfet_01v8 ad=0.1092 pd=1.36 as=0.0441 ps=0.63 w=0.42 l=0.15
X31 VPWR SET_B a_1028_413# VPB sky130_fd_pr__pfet_01v8_hvt ad=0.12075 pd=1.165 as=0.1092 ps=1.36 w=0.42 l=0.15
X32 VGND CLK a_27_47# VNB sky130_fd_pr__nfet_01v8 ad=0.0567 pd=0.69 as=0.1092 ps=1.36 w=0.42 l=0.15
X33 VGND SET_B a_1300_47# VNB sky130_fd_pr__nfet_01v8 ad=0.1137 pd=1.01 as=0.0441 ps=0.63 w=0.42 l=0.15
.ends

.subckt sky130_fd_sc_hd__nand3_1 VPB VNB VGND VPWR A B Y C
X0 VPWR B Y VPB sky130_fd_pr__pfet_01v8_hvt ad=0.165 pd=1.33 as=0.135 ps=1.27 w=1 l=0.15
X1 Y A VPWR VPB sky130_fd_pr__pfet_01v8_hvt ad=0.26 pd=2.52 as=0.165 ps=1.33 w=1 l=0.15
X2 a_193_47# B a_109_47# VNB sky130_fd_pr__nfet_01v8 ad=0.10725 pd=0.98 as=0.08775 ps=0.92 w=0.65 l=0.15
X3 Y A a_193_47# VNB sky130_fd_pr__nfet_01v8 ad=0.169 pd=1.82 as=0.10725 ps=0.98 w=0.65 l=0.15
X4 Y C VPWR VPB sky130_fd_pr__pfet_01v8_hvt ad=0.135 pd=1.27 as=0.26 ps=2.52 w=1 l=0.15
X5 a_109_47# C VGND VNB sky130_fd_pr__nfet_01v8 ad=0.08775 pd=0.92 as=0.169 ps=1.82 w=0.65 l=0.15
.ends

.subckt sky130_fd_sc_hd__nor3_1 VPB VNB VGND VPWR C B A Y
X0 VPWR A a_193_297# VPB sky130_fd_pr__pfet_01v8_hvt ad=0.26 pd=2.52 as=0.135 ps=1.27 w=1 l=0.15
X1 a_193_297# B a_109_297# VPB sky130_fd_pr__pfet_01v8_hvt ad=0.135 pd=1.27 as=0.135 ps=1.27 w=1 l=0.15
X2 Y B VGND VNB sky130_fd_pr__nfet_01v8 ad=0.08775 pd=0.92 as=0.08775 ps=0.92 w=0.65 l=0.15
X3 VGND A Y VNB sky130_fd_pr__nfet_01v8 ad=0.169 pd=1.82 as=0.08775 ps=0.92 w=0.65 l=0.15
X4 a_109_297# C Y VPB sky130_fd_pr__pfet_01v8_hvt ad=0.135 pd=1.27 as=0.26 ps=2.52 w=1 l=0.15
X5 VGND C Y VNB sky130_fd_pr__nfet_01v8 ad=0.08775 pd=0.92 as=0.169 ps=1.82 w=0.65 l=0.15
.ends

.subckt sky130_fd_sc_hd__and2_0 VNB VPB VPWR VGND X B A
X0 VPWR B a_40_47# VPB sky130_fd_pr__pfet_01v8_hvt ad=0.1841 pd=1.26 as=0.0609 ps=0.71 w=0.42 l=0.15
X1 X a_40_47# VPWR VPB sky130_fd_pr__pfet_01v8_hvt ad=0.1696 pd=1.81 as=0.1841 ps=1.26 w=0.64 l=0.15
X2 VGND B a_123_47# VNB sky130_fd_pr__nfet_01v8 ad=0.0966 pd=0.88 as=0.0441 ps=0.63 w=0.42 l=0.15
X3 X a_40_47# VGND VNB sky130_fd_pr__nfet_01v8 ad=0.1113 pd=1.37 as=0.0966 ps=0.88 w=0.42 l=0.15
X4 a_123_47# A a_40_47# VNB sky130_fd_pr__nfet_01v8 ad=0.0441 pd=0.63 as=0.1113 ps=1.37 w=0.42 l=0.15
X5 a_40_47# A VPWR VPB sky130_fd_pr__pfet_01v8_hvt ad=0.0609 pd=0.71 as=0.1113 ps=1.37 w=0.42 l=0.15
.ends

.subckt sky130_fd_sc_hd__buf_16 VNB VPB VGND VPWR A X
X0 VGND A a_109_47# VNB sky130_fd_pr__nfet_01v8 ad=0.08775 pd=0.92 as=0.08775 ps=0.92 w=0.65 l=0.15
X1 X a_109_47# VPWR VPB sky130_fd_pr__pfet_01v8_hvt ad=0.135 pd=1.27 as=0.135 ps=1.27 w=1 l=0.15
X2 VGND a_109_47# X VNB sky130_fd_pr__nfet_01v8 ad=0.08775 pd=0.92 as=0.08775 ps=0.92 w=0.65 l=0.15
X3 VGND a_109_47# X VNB sky130_fd_pr__nfet_01v8 ad=0.08775 pd=0.92 as=0.08775 ps=0.92 w=0.65 l=0.15
X4 X a_109_47# VPWR VPB sky130_fd_pr__pfet_01v8_hvt ad=0.135 pd=1.27 as=0.135 ps=1.27 w=1 l=0.15
X5 VGND a_109_47# X VNB sky130_fd_pr__nfet_01v8 ad=0.08775 pd=0.92 as=0.08775 ps=0.92 w=0.65 l=0.15
X6 VPWR a_109_47# X VPB sky130_fd_pr__pfet_01v8_hvt ad=0.135 pd=1.27 as=0.135 ps=1.27 w=1 l=0.15
X7 a_109_47# A VPWR VPB sky130_fd_pr__pfet_01v8_hvt ad=0.135 pd=1.27 as=0.135 ps=1.27 w=1 l=0.15
X8 X a_109_47# VPWR VPB sky130_fd_pr__pfet_01v8_hvt ad=0.135 pd=1.27 as=0.135 ps=1.27 w=1 l=0.15
X9 VPWR A a_109_47# VPB sky130_fd_pr__pfet_01v8_hvt ad=0.135 pd=1.27 as=0.135 ps=1.27 w=1 l=0.15
X10 X a_109_47# VGND VNB sky130_fd_pr__nfet_01v8 ad=0.08775 pd=0.92 as=0.08775 ps=0.92 w=0.65 l=0.15
X11 X a_109_47# VGND VNB sky130_fd_pr__nfet_01v8 ad=0.08775 pd=0.92 as=0.08775 ps=0.92 w=0.65 l=0.15
X12 X a_109_47# VGND VNB sky130_fd_pr__nfet_01v8 ad=0.08775 pd=0.92 as=0.08775 ps=0.92 w=0.65 l=0.15
X13 X a_109_47# VGND VNB sky130_fd_pr__nfet_01v8 ad=0.08775 pd=0.92 as=0.08775 ps=0.92 w=0.65 l=0.15
X14 a_109_47# A VPWR VPB sky130_fd_pr__pfet_01v8_hvt ad=0.135 pd=1.27 as=0.135 ps=1.27 w=1 l=0.15
X15 VPWR a_109_47# X VPB sky130_fd_pr__pfet_01v8_hvt ad=0.135 pd=1.27 as=0.135 ps=1.27 w=1 l=0.15
X16 X a_109_47# VGND VNB sky130_fd_pr__nfet_01v8 ad=0.08775 pd=0.92 as=0.08775 ps=0.92 w=0.65 l=0.15
X17 X a_109_47# VPWR VPB sky130_fd_pr__pfet_01v8_hvt ad=0.135 pd=1.27 as=0.135 ps=1.27 w=1 l=0.15
X18 VPWR A a_109_47# VPB sky130_fd_pr__pfet_01v8_hvt ad=0.135 pd=1.27 as=0.135 ps=1.27 w=1 l=0.15
X19 VPWR a_109_47# X VPB sky130_fd_pr__pfet_01v8_hvt ad=0.135 pd=1.27 as=0.135 ps=1.27 w=1 l=0.15
X20 VGND A a_109_47# VNB sky130_fd_pr__nfet_01v8 ad=0.08775 pd=0.92 as=0.08775 ps=0.92 w=0.65 l=0.15
X21 VGND A a_109_47# VNB sky130_fd_pr__nfet_01v8 ad=0.08775 pd=0.92 as=0.08775 ps=0.92 w=0.65 l=0.15
X22 VGND a_109_47# X VNB sky130_fd_pr__nfet_01v8 ad=0.08775 pd=0.92 as=0.08775 ps=0.92 w=0.65 l=0.15
X23 X a_109_47# VPWR VPB sky130_fd_pr__pfet_01v8_hvt ad=0.135 pd=1.27 as=0.135 ps=1.27 w=1 l=0.15
X24 VGND a_109_47# X VNB sky130_fd_pr__nfet_01v8 ad=0.08775 pd=0.92 as=0.08775 ps=0.92 w=0.65 l=0.15
X25 VPWR a_109_47# X VPB sky130_fd_pr__pfet_01v8_hvt ad=0.135 pd=1.27 as=0.135 ps=1.27 w=1 l=0.15
X26 VGND a_109_47# X VNB sky130_fd_pr__nfet_01v8 ad=0.08775 pd=0.92 as=0.08775 ps=0.92 w=0.65 l=0.15
X27 VPWR a_109_47# X VPB sky130_fd_pr__pfet_01v8_hvt ad=0.135 pd=1.27 as=0.135 ps=1.27 w=1 l=0.15
X28 X a_109_47# VPWR VPB sky130_fd_pr__pfet_01v8_hvt ad=0.135 pd=1.27 as=0.135 ps=1.27 w=1 l=0.15
X29 VGND a_109_47# X VNB sky130_fd_pr__nfet_01v8 ad=0.169 pd=1.82 as=0.08775 ps=0.92 w=0.65 l=0.15
X30 a_109_47# A VGND VNB sky130_fd_pr__nfet_01v8 ad=0.08775 pd=0.92 as=0.08775 ps=0.92 w=0.65 l=0.15
X31 a_109_47# A VGND VNB sky130_fd_pr__nfet_01v8 ad=0.08775 pd=0.92 as=0.08775 ps=0.92 w=0.65 l=0.15
X32 X a_109_47# VPWR VPB sky130_fd_pr__pfet_01v8_hvt ad=0.135 pd=1.27 as=0.135 ps=1.27 w=1 l=0.15
X33 VPWR a_109_47# X VPB sky130_fd_pr__pfet_01v8_hvt ad=0.135 pd=1.27 as=0.135 ps=1.27 w=1 l=0.15
X34 X a_109_47# VGND VNB sky130_fd_pr__nfet_01v8 ad=0.08775 pd=0.92 as=0.08775 ps=0.92 w=0.65 l=0.15
X35 X a_109_47# VGND VNB sky130_fd_pr__nfet_01v8 ad=0.08775 pd=0.92 as=0.08775 ps=0.92 w=0.65 l=0.15
X36 VPWR A a_109_47# VPB sky130_fd_pr__pfet_01v8_hvt ad=0.135 pd=1.27 as=0.135 ps=1.27 w=1 l=0.15
X37 X a_109_47# VPWR VPB sky130_fd_pr__pfet_01v8_hvt ad=0.135 pd=1.27 as=0.135 ps=1.27 w=1 l=0.15
X38 X a_109_47# VGND VNB sky130_fd_pr__nfet_01v8 ad=0.08775 pd=0.92 as=0.08775 ps=0.92 w=0.65 l=0.15
X39 a_109_47# A VPWR VPB sky130_fd_pr__pfet_01v8_hvt ad=0.135 pd=1.27 as=0.26 ps=2.52 w=1 l=0.15
X40 VPWR a_109_47# X VPB sky130_fd_pr__pfet_01v8_hvt ad=0.135 pd=1.27 as=0.135 ps=1.27 w=1 l=0.15
X41 VPWR a_109_47# X VPB sky130_fd_pr__pfet_01v8_hvt ad=0.26 pd=2.52 as=0.135 ps=1.27 w=1 l=0.15
X42 a_109_47# A VGND VNB sky130_fd_pr__nfet_01v8 ad=0.08775 pd=0.92 as=0.169 ps=1.82 w=0.65 l=0.15
X43 VGND a_109_47# X VNB sky130_fd_pr__nfet_01v8 ad=0.08775 pd=0.92 as=0.08775 ps=0.92 w=0.65 l=0.15
.ends

.subckt sky130_fd_sc_hd__or3_1 VPWR VGND VPB VNB B C A X
X0 X a_29_53# VPWR VPB sky130_fd_pr__pfet_01v8_hvt ad=0.28 pd=2.56 as=0.14825 ps=1.34 w=1 l=0.15
X1 a_111_297# C a_29_53# VPB sky130_fd_pr__pfet_01v8_hvt ad=0.0441 pd=0.63 as=0.1092 ps=1.36 w=0.42 l=0.15
X2 X a_29_53# VGND VNB sky130_fd_pr__nfet_01v8 ad=0.182 pd=1.86 as=0.101875 ps=0.99 w=0.65 l=0.15
X3 a_183_297# B a_111_297# VPB sky130_fd_pr__pfet_01v8_hvt ad=0.0693 pd=0.75 as=0.0441 ps=0.63 w=0.42 l=0.15
X4 VPWR A a_183_297# VPB sky130_fd_pr__pfet_01v8_hvt ad=0.14825 pd=1.34 as=0.0693 ps=0.75 w=0.42 l=0.15
X5 a_29_53# B VGND VNB sky130_fd_pr__nfet_01v8 ad=0.0567 pd=0.69 as=0.0567 ps=0.69 w=0.42 l=0.15
X6 VGND C a_29_53# VNB sky130_fd_pr__nfet_01v8 ad=0.0567 pd=0.69 as=0.1092 ps=1.36 w=0.42 l=0.15
X7 VGND A a_29_53# VNB sky130_fd_pr__nfet_01v8 ad=0.101875 pd=0.99 as=0.0567 ps=0.69 w=0.42 l=0.15
.ends

.subckt sky130_fd_sc_hd__clkbuf_16 VNB VPB VGND VPWR A X
X0 VPWR A a_110_47# VPB sky130_fd_pr__pfet_01v8_hvt ad=0.14 pd=1.28 as=0.14 ps=1.28 w=1 l=0.15
X1 VPWR a_110_47# X VPB sky130_fd_pr__pfet_01v8_hvt ad=0.14 pd=1.28 as=0.14 ps=1.28 w=1 l=0.15
X2 X a_110_47# VPWR VPB sky130_fd_pr__pfet_01v8_hvt ad=0.14 pd=1.28 as=0.14 ps=1.28 w=1 l=0.15
X3 X a_110_47# VPWR VPB sky130_fd_pr__pfet_01v8_hvt ad=0.14 pd=1.28 as=0.14 ps=1.28 w=1 l=0.15
X4 VPWR a_110_47# X VPB sky130_fd_pr__pfet_01v8_hvt ad=0.14 pd=1.28 as=0.14 ps=1.28 w=1 l=0.15
X5 VPWR a_110_47# X VPB sky130_fd_pr__pfet_01v8_hvt ad=0.265 pd=2.53 as=0.14 ps=1.28 w=1 l=0.15
X6 a_110_47# A VPWR VPB sky130_fd_pr__pfet_01v8_hvt ad=0.14 pd=1.28 as=0.265 ps=2.53 w=1 l=0.15
X7 a_110_47# A VGND VNB sky130_fd_pr__nfet_01v8 ad=0.0588 pd=0.7 as=0.0588 ps=0.7 w=0.42 l=0.15
X8 VGND a_110_47# X VNB sky130_fd_pr__nfet_01v8 ad=0.0588 pd=0.7 as=0.0588 ps=0.7 w=0.42 l=0.15
X9 X a_110_47# VGND VNB sky130_fd_pr__nfet_01v8 ad=0.0588 pd=0.7 as=0.0588 ps=0.7 w=0.42 l=0.15
X10 VGND a_110_47# X VNB sky130_fd_pr__nfet_01v8 ad=0.0588 pd=0.7 as=0.0588 ps=0.7 w=0.42 l=0.15
X11 a_110_47# A VPWR VPB sky130_fd_pr__pfet_01v8_hvt ad=0.14 pd=1.28 as=0.14 ps=1.28 w=1 l=0.15
X12 VGND A a_110_47# VNB sky130_fd_pr__nfet_01v8 ad=0.0588 pd=0.7 as=0.0588 ps=0.7 w=0.42 l=0.15
X13 VGND a_110_47# X VNB sky130_fd_pr__nfet_01v8 ad=0.05775 pd=0.695 as=0.0588 ps=0.7 w=0.42 l=0.15
X14 VPWR a_110_47# X VPB sky130_fd_pr__pfet_01v8_hvt ad=0.14 pd=1.28 as=0.14 ps=1.28 w=1 l=0.15
X15 X a_110_47# VPWR VPB sky130_fd_pr__pfet_01v8_hvt ad=0.14 pd=1.28 as=0.14 ps=1.28 w=1 l=0.15
X16 VGND A a_110_47# VNB sky130_fd_pr__nfet_01v8 ad=0.0588 pd=0.7 as=0.0588 ps=0.7 w=0.42 l=0.15
X17 VGND a_110_47# X VNB sky130_fd_pr__nfet_01v8 ad=0.1113 pd=1.37 as=0.0588 ps=0.7 w=0.42 l=0.15
X18 VPWR a_110_47# X VPB sky130_fd_pr__pfet_01v8_hvt ad=0.1375 pd=1.275 as=0.14 ps=1.28 w=1 l=0.15
X19 VGND a_110_47# X VNB sky130_fd_pr__nfet_01v8 ad=0.0588 pd=0.7 as=0.0588 ps=0.7 w=0.42 l=0.15
X20 X a_110_47# VPWR VPB sky130_fd_pr__pfet_01v8_hvt ad=0.14 pd=1.28 as=0.1375 ps=1.275 w=1 l=0.15
X21 a_110_47# A VGND VNB sky130_fd_pr__nfet_01v8 ad=0.0588 pd=0.7 as=0.1113 ps=1.37 w=0.42 l=0.15
X22 VPWR A a_110_47# VPB sky130_fd_pr__pfet_01v8_hvt ad=0.14 pd=1.28 as=0.14 ps=1.28 w=1 l=0.15
X23 VPWR a_110_47# X VPB sky130_fd_pr__pfet_01v8_hvt ad=0.14 pd=1.28 as=0.14 ps=1.28 w=1 l=0.15
X24 VPWR a_110_47# X VPB sky130_fd_pr__pfet_01v8_hvt ad=0.14 pd=1.28 as=0.14 ps=1.28 w=1 l=0.15
X25 VGND a_110_47# X VNB sky130_fd_pr__nfet_01v8 ad=0.0588 pd=0.7 as=0.0588 ps=0.7 w=0.42 l=0.15
X26 X a_110_47# VPWR VPB sky130_fd_pr__pfet_01v8_hvt ad=0.14 pd=1.28 as=0.14 ps=1.28 w=1 l=0.15
X27 VGND a_110_47# X VNB sky130_fd_pr__nfet_01v8 ad=0.0588 pd=0.7 as=0.0588 ps=0.7 w=0.42 l=0.15
X28 VGND a_110_47# X VNB sky130_fd_pr__nfet_01v8 ad=0.0588 pd=0.7 as=0.0588 ps=0.7 w=0.42 l=0.15
X29 X a_110_47# VGND VNB sky130_fd_pr__nfet_01v8 ad=0.0588 pd=0.7 as=0.0588 ps=0.7 w=0.42 l=0.15
X30 X a_110_47# VPWR VPB sky130_fd_pr__pfet_01v8_hvt ad=0.14 pd=1.28 as=0.14 ps=1.28 w=1 l=0.15
X31 X a_110_47# VPWR VPB sky130_fd_pr__pfet_01v8_hvt ad=0.14 pd=1.28 as=0.14 ps=1.28 w=1 l=0.15
X32 X a_110_47# VGND VNB sky130_fd_pr__nfet_01v8 ad=0.0588 pd=0.7 as=0.0588 ps=0.7 w=0.42 l=0.15
X33 VPWR a_110_47# X VPB sky130_fd_pr__pfet_01v8_hvt ad=0.14 pd=1.28 as=0.14 ps=1.28 w=1 l=0.15
X34 X a_110_47# VPWR VPB sky130_fd_pr__pfet_01v8_hvt ad=0.14 pd=1.28 as=0.14 ps=1.28 w=1 l=0.15
X35 X a_110_47# VGND VNB sky130_fd_pr__nfet_01v8 ad=0.0588 pd=0.7 as=0.0588 ps=0.7 w=0.42 l=0.15
X36 X a_110_47# VGND VNB sky130_fd_pr__nfet_01v8 ad=0.0588 pd=0.7 as=0.0588 ps=0.7 w=0.42 l=0.15
X37 X a_110_47# VGND VNB sky130_fd_pr__nfet_01v8 ad=0.0588 pd=0.7 as=0.0588 ps=0.7 w=0.42 l=0.15
X38 X a_110_47# VGND VNB sky130_fd_pr__nfet_01v8 ad=0.0588 pd=0.7 as=0.0588 ps=0.7 w=0.42 l=0.15
X39 X a_110_47# VGND VNB sky130_fd_pr__nfet_01v8 ad=0.0588 pd=0.7 as=0.05775 ps=0.695 w=0.42 l=0.15
.ends

.subckt sky130_fd_sc_hd__or3b_1 VGND VPWR VPB VNB B C_N A X
X0 a_109_93# C_N VGND VNB sky130_fd_pr__nfet_01v8 ad=0.1092 pd=1.36 as=0.1092 ps=1.36 w=0.42 l=0.15
X1 a_215_53# B VGND VNB sky130_fd_pr__nfet_01v8 ad=0.0567 pd=0.69 as=0.0567 ps=0.69 w=0.42 l=0.15
X2 VGND a_109_93# a_215_53# VNB sky130_fd_pr__nfet_01v8 ad=0.0567 pd=0.69 as=0.1092 ps=1.36 w=0.42 l=0.15
X3 VGND A a_215_53# VNB sky130_fd_pr__nfet_01v8 ad=0.10025 pd=0.985 as=0.0567 ps=0.69 w=0.42 l=0.15
X4 VPWR A a_369_297# VPB sky130_fd_pr__pfet_01v8_hvt ad=0.14825 pd=1.34 as=0.06825 ps=0.745 w=0.42 l=0.15
X5 a_369_297# B a_297_297# VPB sky130_fd_pr__pfet_01v8_hvt ad=0.06825 pd=0.745 as=0.0441 ps=0.63 w=0.42 l=0.15
X6 X a_215_53# VPWR VPB sky130_fd_pr__pfet_01v8_hvt ad=0.275 pd=2.55 as=0.14825 ps=1.34 w=1 l=0.15
X7 a_297_297# a_109_93# a_215_53# VPB sky130_fd_pr__pfet_01v8_hvt ad=0.0441 pd=0.63 as=0.1092 ps=1.36 w=0.42 l=0.15
X8 a_109_93# C_N VPWR VPB sky130_fd_pr__pfet_01v8_hvt ad=0.1092 pd=1.36 as=0.1092 ps=1.36 w=0.42 l=0.15
X9 X a_215_53# VGND VNB sky130_fd_pr__nfet_01v8 ad=0.17875 pd=1.85 as=0.10025 ps=0.985 w=0.65 l=0.15
.ends

.subckt sky130_fd_sc_hd__a21o_1 VPWR VGND VPB VNB A2 A1 B1 X
X0 a_81_21# B1 VGND VNB sky130_fd_pr__nfet_01v8 ad=0.089375 pd=0.925 as=0.25675 ps=1.44 w=0.65 l=0.15
X1 a_299_297# B1 a_81_21# VPB sky130_fd_pr__pfet_01v8_hvt ad=0.1375 pd=1.275 as=0.26 ps=2.52 w=1 l=0.15
X2 VPWR a_81_21# X VPB sky130_fd_pr__pfet_01v8_hvt ad=0.26 pd=2.52 as=0.26 ps=2.52 w=1 l=0.15
X3 VPWR A1 a_299_297# VPB sky130_fd_pr__pfet_01v8_hvt ad=0.14 pd=1.28 as=0.1375 ps=1.275 w=1 l=0.15
X4 VGND a_81_21# X VNB sky130_fd_pr__nfet_01v8 ad=0.25675 pd=1.44 as=0.169 ps=1.82 w=0.65 l=0.15
X5 VGND A2 a_384_47# VNB sky130_fd_pr__nfet_01v8 ad=0.17225 pd=1.83 as=0.091 ps=0.93 w=0.65 l=0.15
X6 a_299_297# A2 VPWR VPB sky130_fd_pr__pfet_01v8_hvt ad=0.265 pd=2.53 as=0.14 ps=1.28 w=1 l=0.15
X7 a_384_47# A1 a_81_21# VNB sky130_fd_pr__nfet_01v8 ad=0.091 pd=0.93 as=0.089375 ps=0.925 w=0.65 l=0.15
.ends

.subckt sky130_fd_sc_hd__o21ai_0 VNB VPB VGND VPWR B1 A1 Y A2
X0 a_120_369# A1 VPWR VPB sky130_fd_pr__pfet_01v8_hvt ad=0.0768 pd=0.88 as=0.1696 ps=1.81 w=0.64 l=0.15
X1 VGND A1 a_32_47# VNB sky130_fd_pr__nfet_01v8 ad=0.0588 pd=0.7 as=0.1113 ps=1.37 w=0.42 l=0.15
X2 Y A2 a_120_369# VPB sky130_fd_pr__pfet_01v8_hvt ad=0.0896 pd=0.92 as=0.0768 ps=0.88 w=0.64 l=0.15
X3 a_32_47# A2 VGND VNB sky130_fd_pr__nfet_01v8 ad=0.0588 pd=0.7 as=0.0588 ps=0.7 w=0.42 l=0.15
X4 VPWR B1 Y VPB sky130_fd_pr__pfet_01v8_hvt ad=0.1824 pd=1.85 as=0.0896 ps=0.92 w=0.64 l=0.15
X5 Y B1 a_32_47# VNB sky130_fd_pr__nfet_01v8 ad=0.1113 pd=1.37 as=0.0588 ps=0.7 w=0.42 l=0.15
.ends

.subckt sky130_fd_sc_hd__or4_1 VPWR VGND VPB VNB B D C A X
X0 a_27_297# B VGND VNB sky130_fd_pr__nfet_01v8 ad=0.0567 pd=0.69 as=0.0567 ps=0.69 w=0.42 l=0.15
X1 a_27_297# D VGND VNB sky130_fd_pr__nfet_01v8 ad=0.0693 pd=0.75 as=0.1092 ps=1.36 w=0.42 l=0.15
X2 a_277_297# B a_205_297# VPB sky130_fd_pr__pfet_01v8_hvt ad=0.0693 pd=0.75 as=0.0441 ps=0.63 w=0.42 l=0.15
X3 VPWR A a_277_297# VPB sky130_fd_pr__pfet_01v8_hvt ad=0.14825 pd=1.34 as=0.0693 ps=0.75 w=0.42 l=0.15
X4 X a_27_297# VGND VNB sky130_fd_pr__nfet_01v8 ad=0.1755 pd=1.84 as=0.101875 ps=0.99 w=0.65 l=0.15
X5 a_205_297# C a_109_297# VPB sky130_fd_pr__pfet_01v8_hvt ad=0.0441 pd=0.63 as=0.0693 ps=0.75 w=0.42 l=0.15
X6 X a_27_297# VPWR VPB sky130_fd_pr__pfet_01v8_hvt ad=0.27 pd=2.54 as=0.14825 ps=1.34 w=1 l=0.15
X7 VGND C a_27_297# VNB sky130_fd_pr__nfet_01v8 ad=0.0567 pd=0.69 as=0.0693 ps=0.75 w=0.42 l=0.15
X8 a_109_297# D a_27_297# VPB sky130_fd_pr__pfet_01v8_hvt ad=0.0693 pd=0.75 as=0.1092 ps=1.36 w=0.42 l=0.15
X9 VGND A a_27_297# VNB sky130_fd_pr__nfet_01v8 ad=0.101875 pd=0.99 as=0.0567 ps=0.69 w=0.42 l=0.15
.ends

.subckt sky130_fd_sc_hd__a31o_1 VPB VNB X A3 A2 A1 B1 VGND VPWR
X0 VPWR a_80_21# X VPB sky130_fd_pr__pfet_01v8_hvt ad=0.1725 pd=1.345 as=0.265 ps=2.53 w=1 l=0.15
X1 a_209_297# A3 VPWR VPB sky130_fd_pr__pfet_01v8_hvt ad=0.16 pd=1.32 as=0.1725 ps=1.345 w=1 l=0.15
X2 a_303_47# A2 a_209_47# VNB sky130_fd_pr__nfet_01v8 ad=0.10725 pd=0.98 as=0.104 ps=0.97 w=0.65 l=0.15
X3 a_209_47# A3 VGND VNB sky130_fd_pr__nfet_01v8 ad=0.104 pd=0.97 as=0.112125 ps=0.995 w=0.65 l=0.15
X4 VGND a_80_21# X VNB sky130_fd_pr__nfet_01v8 ad=0.112125 pd=0.995 as=0.17225 ps=1.83 w=0.65 l=0.15
X5 VGND B1 a_80_21# VNB sky130_fd_pr__nfet_01v8 ad=0.208 pd=1.94 as=0.10725 ps=0.98 w=0.65 l=0.15
X6 a_80_21# A1 a_303_47# VNB sky130_fd_pr__nfet_01v8 ad=0.10725 pd=0.98 as=0.10725 ps=0.98 w=0.65 l=0.15
X7 VPWR A2 a_209_297# VPB sky130_fd_pr__pfet_01v8_hvt ad=0.165 pd=1.33 as=0.16 ps=1.32 w=1 l=0.15
X8 a_80_21# B1 a_209_297# VPB sky130_fd_pr__pfet_01v8_hvt ad=0.32 pd=2.64 as=0.165 ps=1.33 w=1 l=0.15
X9 a_209_297# A1 VPWR VPB sky130_fd_pr__pfet_01v8_hvt ad=0.165 pd=1.33 as=0.165 ps=1.33 w=1 l=0.15
.ends

.subckt sky130_fd_sc_hd__o211ai_1 VPB VNB VGND VPWR A1 Y C1 B1 A2
X0 a_110_297# A1 VPWR VPB sky130_fd_pr__pfet_01v8_hvt ad=0.105 pd=1.21 as=0.265 ps=2.53 w=1 l=0.15
X1 VGND A1 a_27_47# VNB sky130_fd_pr__nfet_01v8 ad=0.12675 pd=1.04 as=0.17225 ps=1.83 w=0.65 l=0.15
X2 Y A2 a_110_297# VPB sky130_fd_pr__pfet_01v8_hvt ad=0.195 pd=1.39 as=0.105 ps=1.21 w=1 l=0.15
X3 VPWR B1 Y VPB sky130_fd_pr__pfet_01v8_hvt ad=0.195 pd=1.39 as=0.195 ps=1.39 w=1 l=0.15
X4 a_27_47# A2 VGND VNB sky130_fd_pr__nfet_01v8 ad=0.12675 pd=1.04 as=0.12675 ps=1.04 w=0.65 l=0.15
X5 a_326_47# B1 a_27_47# VNB sky130_fd_pr__nfet_01v8 ad=0.06825 pd=0.86 as=0.12675 ps=1.04 w=0.65 l=0.15
X6 Y C1 VPWR VPB sky130_fd_pr__pfet_01v8_hvt ad=0.635 pd=3.27 as=0.195 ps=1.39 w=1 l=0.15
X7 Y C1 a_326_47# VNB sky130_fd_pr__nfet_01v8 ad=0.39325 pd=2.51 as=0.06825 ps=0.86 w=0.65 l=0.15
.ends

.subckt sky130_fd_sc_hd__a32o_1 VGND VPWR VPB VNB X A3 A2 A1 B1 B2
X0 a_93_21# A1 a_346_47# VNB sky130_fd_pr__nfet_01v8 ad=0.143 pd=1.09 as=0.14625 ps=1.1 w=0.65 l=0.15
X1 a_93_21# B1 a_250_297# VPB sky130_fd_pr__pfet_01v8_hvt ad=0.14 pd=1.28 as=0.185 ps=1.37 w=1 l=0.15
X2 a_584_47# B1 a_93_21# VNB sky130_fd_pr__nfet_01v8 ad=0.06825 pd=0.86 as=0.143 ps=1.09 w=0.65 l=0.15
X3 VPWR a_93_21# X VPB sky130_fd_pr__pfet_01v8_hvt ad=0.2425 pd=1.485 as=0.33 ps=2.66 w=1 l=0.15
X4 VGND B2 a_584_47# VNB sky130_fd_pr__nfet_01v8 ad=0.17225 pd=1.83 as=0.06825 ps=0.86 w=0.65 l=0.15
X5 a_256_47# A3 VGND VNB sky130_fd_pr__nfet_01v8 ad=0.0975 pd=0.95 as=0.167375 ps=1.165 w=0.65 l=0.15
X6 a_250_297# B2 a_93_21# VPB sky130_fd_pr__pfet_01v8_hvt ad=0.265 pd=2.53 as=0.14 ps=1.28 w=1 l=0.15
X7 VGND a_93_21# X VNB sky130_fd_pr__nfet_01v8 ad=0.167375 pd=1.165 as=0.2145 ps=1.96 w=0.65 l=0.15
X8 a_250_297# A3 VPWR VPB sky130_fd_pr__pfet_01v8_hvt ad=0.165 pd=1.33 as=0.2425 ps=1.485 w=1 l=0.15
X9 VPWR A2 a_250_297# VPB sky130_fd_pr__pfet_01v8_hvt ad=0.225 pd=1.45 as=0.165 ps=1.33 w=1 l=0.15
X10 a_250_297# A1 VPWR VPB sky130_fd_pr__pfet_01v8_hvt ad=0.185 pd=1.37 as=0.225 ps=1.45 w=1 l=0.15
X11 a_346_47# A2 a_256_47# VNB sky130_fd_pr__nfet_01v8 ad=0.14625 pd=1.1 as=0.0975 ps=0.95 w=0.65 l=0.15
.ends

.subckt sky130_fd_sc_hd__o21a_1 VPB VNB VGND VPWR A1 A2 B1 X
X0 VPWR A1 a_382_297# VPB sky130_fd_pr__pfet_01v8_hvt ad=0.26 pd=2.52 as=0.1525 ps=1.305 w=1 l=0.15
X1 a_297_47# B1 a_79_21# VNB sky130_fd_pr__nfet_01v8 ad=0.10075 pd=0.96 as=0.169 ps=1.82 w=0.65 l=0.15
X2 a_297_47# A1 VGND VNB sky130_fd_pr__nfet_01v8 ad=0.169 pd=1.82 as=0.08775 ps=0.92 w=0.65 l=0.15
X3 VGND A2 a_297_47# VNB sky130_fd_pr__nfet_01v8 ad=0.08775 pd=0.92 as=0.10075 ps=0.96 w=0.65 l=0.15
X4 VPWR a_79_21# X VPB sky130_fd_pr__pfet_01v8_hvt ad=0.3275 pd=1.655 as=0.28 ps=2.56 w=1 l=0.15
X5 a_79_21# B1 VPWR VPB sky130_fd_pr__pfet_01v8_hvt ad=0.195 pd=1.39 as=0.3275 ps=1.655 w=1 l=0.15
X6 a_382_297# A2 a_79_21# VPB sky130_fd_pr__pfet_01v8_hvt ad=0.1525 pd=1.305 as=0.195 ps=1.39 w=1 l=0.15
X7 VGND a_79_21# X VNB sky130_fd_pr__nfet_01v8 ad=0.169 pd=1.82 as=0.169 ps=1.82 w=0.65 l=0.15
.ends

.subckt sky130_fd_sc_hd__a22o_1 VPWR VGND VPB VNB B1 A1 A2 X B2
X0 VPWR A2 a_109_297# VPB sky130_fd_pr__pfet_01v8_hvt ad=0.155 pd=1.31 as=0.16 ps=1.32 w=1 l=0.15
X1 a_27_297# B1 a_109_47# VNB sky130_fd_pr__nfet_01v8 ad=0.169 pd=1.82 as=0.07475 ps=0.88 w=0.65 l=0.15
X2 VGND A2 a_373_47# VNB sky130_fd_pr__nfet_01v8 ad=0.10075 pd=0.96 as=0.11375 ps=1 w=0.65 l=0.15
X3 X a_27_297# VPWR VPB sky130_fd_pr__pfet_01v8_hvt ad=0.26 pd=2.52 as=0.155 ps=1.31 w=1 l=0.15
X4 a_27_297# B1 a_109_297# VPB sky130_fd_pr__pfet_01v8_hvt ad=0.25285 pd=2.52 as=0.135 ps=1.27 w=1 l=0.15
X5 a_109_297# A1 VPWR VPB sky130_fd_pr__pfet_01v8_hvt ad=0.16 pd=1.32 as=0.2529 ps=2.52 w=1 l=0.15
X6 a_373_47# A1 a_27_297# VNB sky130_fd_pr__nfet_01v8 ad=0.11375 pd=1 as=0.169 ps=1.82 w=0.65 l=0.15
X7 X a_27_297# VGND VNB sky130_fd_pr__nfet_01v8 ad=0.169 pd=1.82 as=0.10075 ps=0.96 w=0.65 l=0.15
X8 a_109_297# B2 a_27_297# VPB sky130_fd_pr__pfet_01v8_hvt ad=0.135 pd=1.27 as=0.26 ps=2.52 w=1 l=0.15
X9 a_109_47# B2 VGND VNB sky130_fd_pr__nfet_01v8 ad=0.07475 pd=0.88 as=0.169 ps=1.82 w=0.65 l=0.15
.ends

.subckt sky130_fd_sc_hd__a211oi_1 VPWR VGND VPB VNB Y C1 B1 A1 A2
X0 a_56_297# A1 VPWR VPB sky130_fd_pr__pfet_01v8_hvt ad=0.14 pd=1.28 as=0.14 ps=1.28 w=1 l=0.15
X1 VPWR A2 a_56_297# VPB sky130_fd_pr__pfet_01v8_hvt ad=0.14 pd=1.28 as=0.265 ps=2.53 w=1 l=0.15
X2 Y C1 VGND VNB sky130_fd_pr__nfet_01v8 ad=0.17225 pd=1.83 as=0.10075 ps=0.96 w=0.65 l=0.15
X3 a_139_47# A2 VGND VNB sky130_fd_pr__nfet_01v8 ad=0.091 pd=0.93 as=0.2665 ps=2.12 w=0.65 l=0.15
X4 a_311_297# B1 a_56_297# VPB sky130_fd_pr__pfet_01v8_hvt ad=0.155 pd=1.31 as=0.14 ps=1.28 w=1 l=0.15
X5 Y C1 a_311_297# VPB sky130_fd_pr__pfet_01v8_hvt ad=0.265 pd=2.53 as=0.155 ps=1.31 w=1 l=0.15
X6 VGND B1 Y VNB sky130_fd_pr__nfet_01v8 ad=0.10075 pd=0.96 as=0.091 ps=0.93 w=0.65 l=0.15
X7 Y A1 a_139_47# VNB sky130_fd_pr__nfet_01v8 ad=0.091 pd=0.93 as=0.091 ps=0.93 w=0.65 l=0.15
.ends

.subckt sky130_fd_sc_hd__nand4b_1 VPB VNB VGND VPWR Y C B D A_N
X0 Y B VPWR VPB sky130_fd_pr__pfet_01v8_hvt ad=0.195 pd=1.39 as=0.1925 ps=1.385 w=1 l=0.15
X1 a_232_47# D VGND VNB sky130_fd_pr__nfet_01v8 ad=0.08775 pd=0.92 as=0.118125 ps=1.04 w=0.65 l=0.15
X2 VPWR C Y VPB sky130_fd_pr__pfet_01v8_hvt ad=0.1925 pd=1.385 as=0.135 ps=1.27 w=1 l=0.15
X3 VPWR A_N a_41_93# VPB sky130_fd_pr__pfet_01v8_hvt ad=0.14575 pd=1.335 as=0.1092 ps=1.36 w=0.42 l=0.15
X4 VPWR a_41_93# Y VPB sky130_fd_pr__pfet_01v8_hvt ad=0.28 pd=2.56 as=0.195 ps=1.39 w=1 l=0.15
X5 a_316_47# C a_232_47# VNB sky130_fd_pr__nfet_01v8 ad=0.125125 pd=1.035 as=0.08775 ps=0.92 w=0.65 l=0.15
X6 Y a_41_93# a_423_47# VNB sky130_fd_pr__nfet_01v8 ad=0.2275 pd=2 as=0.12675 ps=1.04 w=0.65 l=0.15
X7 a_423_47# B a_316_47# VNB sky130_fd_pr__nfet_01v8 ad=0.12675 pd=1.04 as=0.125125 ps=1.035 w=0.65 l=0.15
X8 Y D VPWR VPB sky130_fd_pr__pfet_01v8_hvt ad=0.135 pd=1.27 as=0.14575 ps=1.335 w=1 l=0.15
X9 VGND A_N a_41_93# VNB sky130_fd_pr__nfet_01v8 ad=0.118125 pd=1.04 as=0.1113 ps=1.37 w=0.42 l=0.15
.ends

.subckt sky130_fd_sc_hd__diode_2 DIODE VGND VPWR VPB VNB
D0 VNB DIODE sky130_fd_pr__diode_pw2nd_05v5 pj=2.64e+06 area=4.347e+11
.ends

.subckt sky130_fd_sc_hd__dfrtp_4 VGND VPWR VPB VNB CLK D RESET_B Q
X0 a_1217_47# a_27_47# a_1108_47# VNB sky130_fd_pr__nfet_01v8 ad=0.0669 pd=0.75 as=0.0711 ps=0.755 w=0.36 l=0.15
X1 a_805_47# a_761_289# a_639_47# VNB sky130_fd_pr__nfet_01v8 ad=0.0441 pd=0.63 as=0.1401 ps=1.1 w=0.42 l=0.15
X2 a_1108_47# a_193_47# a_761_289# VNB sky130_fd_pr__nfet_01v8 ad=0.0711 pd=0.755 as=0.0999 ps=0.985 w=0.36 l=0.15
X3 a_1283_21# a_1108_47# a_1462_47# VNB sky130_fd_pr__nfet_01v8 ad=0.1092 pd=1.36 as=0.06405 ps=0.725 w=0.42 l=0.15
X4 a_651_413# a_27_47# a_543_47# VPB sky130_fd_pr__pfet_01v8_hvt ad=0.1155 pd=0.97 as=0.07245 ps=0.765 w=0.42 l=0.15
X5 VGND RESET_B a_805_47# VNB sky130_fd_pr__nfet_01v8 ad=0.1346 pd=1.15 as=0.0441 ps=0.63 w=0.42 l=0.15
X6 VPWR a_1283_21# Q VPB sky130_fd_pr__pfet_01v8_hvt ad=0.305 pd=2.61 as=0.135 ps=1.27 w=1 l=0.15
X7 VPWR CLK a_27_47# VPB sky130_fd_pr__pfet_01v8_hvt ad=0.0864 pd=0.91 as=0.1664 ps=1.8 w=0.64 l=0.15
X8 a_448_47# D VPWR VPB sky130_fd_pr__pfet_01v8_hvt ad=0.0651 pd=0.73 as=0.1092 ps=1.36 w=0.42 l=0.15
X9 Q a_1283_21# VPWR VPB sky130_fd_pr__pfet_01v8_hvt ad=0.135 pd=1.27 as=0.135 ps=1.27 w=1 l=0.15
X10 VPWR a_1283_21# Q VPB sky130_fd_pr__pfet_01v8_hvt ad=0.135 pd=1.27 as=0.135 ps=1.27 w=1 l=0.15
X11 a_761_289# a_543_47# VGND VNB sky130_fd_pr__nfet_01v8 ad=0.0999 pd=0.985 as=0.1346 ps=1.15 w=0.64 l=0.15
X12 Q a_1283_21# VGND VNB sky130_fd_pr__nfet_01v8 ad=0.08775 pd=0.92 as=0.169 ps=1.82 w=0.65 l=0.15
X13 a_193_47# a_27_47# VGND VNB sky130_fd_pr__nfet_01v8 ad=0.1092 pd=1.36 as=0.0567 ps=0.69 w=0.42 l=0.15
X14 a_1108_47# a_27_47# a_761_289# VPB sky130_fd_pr__pfet_01v8_hvt ad=0.0588 pd=0.7 as=0.12915 ps=1.185 w=0.42 l=0.15
X15 a_543_47# a_27_47# a_448_47# VNB sky130_fd_pr__nfet_01v8 ad=0.0594 pd=0.69 as=0.066 ps=0.745 w=0.36 l=0.15
X16 a_1462_47# RESET_B VGND VNB sky130_fd_pr__nfet_01v8 ad=0.06405 pd=0.725 as=0.12495 ps=1.015 w=0.42 l=0.15
X17 a_543_47# a_193_47# a_448_47# VPB sky130_fd_pr__pfet_01v8_hvt ad=0.07245 pd=0.765 as=0.0651 ps=0.73 w=0.42 l=0.15
X18 a_448_47# D VGND VNB sky130_fd_pr__nfet_01v8 ad=0.066 pd=0.745 as=0.2205 ps=1.89 w=0.42 l=0.15
X19 VPWR a_1283_21# a_1270_413# VPB sky130_fd_pr__pfet_01v8_hvt ad=0.0819 pd=0.81 as=0.0567 ps=0.69 w=0.42 l=0.15
X20 VPWR a_1108_47# a_1283_21# VPB sky130_fd_pr__pfet_01v8_hvt ad=0.1134 pd=1.38 as=0.0567 ps=0.69 w=0.42 l=0.15
X21 Q a_1283_21# VPWR VPB sky130_fd_pr__pfet_01v8_hvt ad=0.135 pd=1.27 as=0.26 ps=2.52 w=1 l=0.15
X22 a_1270_413# a_193_47# a_1108_47# VPB sky130_fd_pr__pfet_01v8_hvt ad=0.0567 pd=0.69 as=0.0588 ps=0.7 w=0.42 l=0.15
X23 a_193_47# a_27_47# VPWR VPB sky130_fd_pr__pfet_01v8_hvt ad=0.1664 pd=1.8 as=0.0864 ps=0.91 w=0.64 l=0.15
X24 a_1283_21# RESET_B VPWR VPB sky130_fd_pr__pfet_01v8_hvt ad=0.0567 pd=0.69 as=0.0819 ps=0.81 w=0.42 l=0.15
X25 VGND a_1283_21# Q VNB sky130_fd_pr__nfet_01v8 ad=0.08775 pd=0.92 as=0.08775 ps=0.92 w=0.65 l=0.15
X26 VGND a_1283_21# Q VNB sky130_fd_pr__nfet_01v8 ad=0.182 pd=1.86 as=0.08775 ps=0.92 w=0.65 l=0.15
X27 VPWR a_761_289# a_651_413# VPB sky130_fd_pr__pfet_01v8_hvt ad=0.07035 pd=0.755 as=0.1155 ps=0.97 w=0.42 l=0.15
X28 a_639_47# a_193_47# a_543_47# VNB sky130_fd_pr__nfet_01v8 ad=0.1401 pd=1.1 as=0.0594 ps=0.69 w=0.36 l=0.15
X29 VGND a_1283_21# a_1217_47# VNB sky130_fd_pr__nfet_01v8 ad=0.12495 pd=1.015 as=0.0669 ps=0.75 w=0.42 l=0.15
X30 a_651_413# RESET_B VPWR VPB sky130_fd_pr__pfet_01v8_hvt ad=0.1092 pd=1.36 as=0.07035 ps=0.755 w=0.42 l=0.15
X31 VGND CLK a_27_47# VNB sky130_fd_pr__nfet_01v8 ad=0.0567 pd=0.69 as=0.1092 ps=1.36 w=0.42 l=0.15
X32 a_761_289# a_543_47# VPWR VPB sky130_fd_pr__pfet_01v8_hvt ad=0.12915 pd=1.185 as=0.2184 ps=2.2 w=0.84 l=0.15
X33 Q a_1283_21# VGND VNB sky130_fd_pr__nfet_01v8 ad=0.08775 pd=0.92 as=0.08775 ps=0.92 w=0.65 l=0.15
.ends

.subckt sky130_fd_sc_hd__o311a_1 X A1 A2 A3 B1 C1 VPB VNB VGND VPWR
X0 a_585_47# B1 a_266_47# VNB sky130_fd_pr__nfet_01v8 ad=0.06825 pd=0.86 as=0.118625 ps=1.015 w=0.65 l=0.15
X1 VGND A2 a_266_47# VNB sky130_fd_pr__nfet_01v8 ad=0.1365 pd=1.07 as=0.117 ps=1.01 w=0.65 l=0.15
X2 VPWR a_81_21# X VPB sky130_fd_pr__pfet_01v8_hvt ad=0.3125 pd=1.625 as=0.26 ps=2.52 w=1 l=0.15
X3 a_81_21# C1 a_585_47# VNB sky130_fd_pr__nfet_01v8 ad=0.169 pd=1.82 as=0.06825 ps=0.86 w=0.65 l=0.15
X4 VGND a_81_21# X VNB sky130_fd_pr__nfet_01v8 ad=0.203125 pd=1.275 as=0.169 ps=1.82 w=0.65 l=0.15
X5 a_266_297# A1 VPWR VPB sky130_fd_pr__pfet_01v8_hvt ad=0.18 pd=1.36 as=0.3125 ps=1.625 w=1 l=0.15
X6 a_368_297# A2 a_266_297# VPB sky130_fd_pr__pfet_01v8_hvt ad=0.21 pd=1.42 as=0.18 ps=1.36 w=1 l=0.15
X7 a_266_47# A3 VGND VNB sky130_fd_pr__nfet_01v8 ad=0.118625 pd=1.015 as=0.1365 ps=1.07 w=0.65 l=0.15
X8 a_266_47# A1 VGND VNB sky130_fd_pr__nfet_01v8 ad=0.117 pd=1.01 as=0.203125 ps=1.275 w=0.65 l=0.15
X9 a_81_21# A3 a_368_297# VPB sky130_fd_pr__pfet_01v8_hvt ad=0.1375 pd=1.275 as=0.21 ps=1.42 w=1 l=0.15
X10 a_81_21# C1 VPWR VPB sky130_fd_pr__pfet_01v8_hvt ad=0.26 pd=2.52 as=0.15 ps=1.3 w=1 l=0.15
X11 VPWR B1 a_81_21# VPB sky130_fd_pr__pfet_01v8_hvt ad=0.15 pd=1.3 as=0.1375 ps=1.275 w=1 l=0.15
.ends

.subckt sky130_fd_sc_hd__o31ai_1 VPB VNB A1 A2 A3 Y B1 VPWR VGND
X0 Y B1 a_109_47# VNB sky130_fd_pr__nfet_01v8 ad=0.221 pd=1.98 as=0.19825 ps=1.26 w=0.65 l=0.15
X1 Y A3 a_193_297# VPB sky130_fd_pr__pfet_01v8_hvt ad=0.3925 pd=1.785 as=0.135 ps=1.27 w=1 l=0.15
X2 a_193_297# A2 a_109_297# VPB sky130_fd_pr__pfet_01v8_hvt ad=0.135 pd=1.27 as=0.135 ps=1.27 w=1 l=0.15
X3 VGND A2 a_109_47# VNB sky130_fd_pr__nfet_01v8 ad=0.08775 pd=0.92 as=0.08775 ps=0.92 w=0.65 l=0.15
X4 VPWR B1 Y VPB sky130_fd_pr__pfet_01v8_hvt ad=0.3 pd=2.6 as=0.3925 ps=1.785 w=1 l=0.15
X5 a_109_47# A3 VGND VNB sky130_fd_pr__nfet_01v8 ad=0.19825 pd=1.26 as=0.08775 ps=0.92 w=0.65 l=0.15
X6 a_109_297# A1 VPWR VPB sky130_fd_pr__pfet_01v8_hvt ad=0.135 pd=1.27 as=0.26 ps=2.52 w=1 l=0.15
X7 a_109_47# A1 VGND VNB sky130_fd_pr__nfet_01v8 ad=0.08775 pd=0.92 as=0.169 ps=1.82 w=0.65 l=0.15
.ends

.subckt sky130_fd_sc_hd__nor4b_1 VPB VNB VGND VPWR D_N C Y B A
X0 Y a_91_199# VGND VNB sky130_fd_pr__nfet_01v8 ad=0.08775 pd=0.92 as=0.182 ps=1.86 w=0.65 l=0.15
X1 Y B VGND VNB sky130_fd_pr__nfet_01v8 ad=0.08775 pd=0.92 as=0.10725 ps=0.98 w=0.65 l=0.15
X2 VGND C Y VNB sky130_fd_pr__nfet_01v8 ad=0.10725 pd=0.98 as=0.08775 ps=0.92 w=0.65 l=0.15
X3 a_91_199# D_N VGND VNB sky130_fd_pr__nfet_01v8 ad=0.1092 pd=1.36 as=0.10025 ps=0.985 w=0.42 l=0.15
X4 VGND A Y VNB sky130_fd_pr__nfet_01v8 ad=0.10025 pd=0.985 as=0.08775 ps=0.92 w=0.65 l=0.15
X5 VPWR A a_341_297# VPB sky130_fd_pr__pfet_01v8_hvt ad=0.14575 pd=1.335 as=0.135 ps=1.27 w=1 l=0.15
X6 a_245_297# C a_161_297# VPB sky130_fd_pr__pfet_01v8_hvt ad=0.165 pd=1.33 as=0.135 ps=1.27 w=1 l=0.15
X7 a_341_297# B a_245_297# VPB sky130_fd_pr__pfet_01v8_hvt ad=0.135 pd=1.27 as=0.165 ps=1.33 w=1 l=0.15
X8 a_91_199# D_N VPWR VPB sky130_fd_pr__pfet_01v8_hvt ad=0.1092 pd=1.36 as=0.14575 ps=1.335 w=0.42 l=0.15
X9 a_161_297# a_91_199# Y VPB sky130_fd_pr__pfet_01v8_hvt ad=0.135 pd=1.27 as=0.52 ps=3.04 w=1 l=0.15
.ends

.subckt sky130_fd_sc_hd__nor2b_1 VPB VNB VGND VPWR B_N A Y
X0 Y a_74_47# a_265_297# VPB sky130_fd_pr__pfet_01v8_hvt ad=0.26 pd=2.52 as=0.105 ps=1.21 w=1 l=0.15
X1 VPWR B_N a_74_47# VPB sky130_fd_pr__pfet_01v8_hvt ad=0.1573 pd=1.39 as=0.1092 ps=1.36 w=0.42 l=0.15
X2 a_265_297# A VPWR VPB sky130_fd_pr__pfet_01v8_hvt ad=0.105 pd=1.21 as=0.1573 ps=1.39 w=1 l=0.15
X3 Y A VGND VNB sky130_fd_pr__nfet_01v8 ad=0.08775 pd=0.92 as=0.10025 ps=0.985 w=0.65 l=0.15
X4 VGND B_N a_74_47# VNB sky130_fd_pr__nfet_01v8 ad=0.10025 pd=0.985 as=0.1092 ps=1.36 w=0.42 l=0.15
X5 VGND a_74_47# Y VNB sky130_fd_pr__nfet_01v8 ad=0.169 pd=1.82 as=0.08775 ps=0.92 w=0.65 l=0.15
.ends

.subckt axi2uart_bridge_top s_axi_aclk s_axi_aresetn s_axi_awaddr[0] s_axi_awaddr[1]
+ s_axi_awaddr[2] s_axi_awaddr[3] s_axi_awvalid s_axi_bready s_axi_bresp[1] s_axi_bvalid
+ s_axi_wdata[0] s_axi_wdata[10] s_axi_wdata[11] s_axi_wdata[12] s_axi_wdata[13] s_axi_wdata[14]
+ s_axi_wdata[15] s_axi_wdata[16] s_axi_wdata[17] s_axi_wdata[18] s_axi_wdata[19]
+ s_axi_wdata[1] s_axi_wdata[20] s_axi_wdata[21] s_axi_wdata[22] s_axi_wdata[23] s_axi_wdata[24]
+ s_axi_wdata[25] s_axi_wdata[26] s_axi_wdata[27] s_axi_wdata[28] s_axi_wdata[29]
+ s_axi_wdata[2] s_axi_wdata[30] s_axi_wdata[31] s_axi_wdata[3] s_axi_wdata[4] s_axi_wdata[5]
+ s_axi_wdata[6] s_axi_wdata[7] s_axi_wdata[8] s_axi_wdata[9] s_axi_wready s_axi_wstrb[0]
+ s_axi_wstrb[1] s_axi_wstrb[2] s_axi_wstrb[3] s_axi_wvalid uart_clk uart_rst_n uart_tx_out
XPHY_EDGE_ROW_15_Left_82 PHY_EDGE_ROW_15_Left_82/VPWR PHY_EDGE_ROW_16_Left_83/VGND
+ PHY_EDGE_ROW_15_Left_82/VPB VSUBS sky130_fd_sc_hd__decap_3
Xu_axi_slave__216_ VSUBS u_axi_slave__216_/VPWR u_axi_slave__216_/VPB VSUBS u_axi_slave__216_/CLK
+ u_axi_slave__216_/D u_axi_slave__216_/RESET_B u_axi_slave__216_/Q sky130_fd_sc_hd__dfrtp_1
Xu_axi_slave__147_ u_axi_slave__209_/VPB VSUBS VSUBS u_axi_slave__209_/VPB u_axi_slave__147_/A
+ u_axi_slave__147_/B u_axi_slave__147_/Y sky130_fd_sc_hd__nor2_1
Xu_uart_tx__133_ u_uart_tx__166_/VPB VSUBS VSUBS u_uart_tx__166_/VPB u_uart_tx__133_/A1
+ u_uart_tx__133_/A2 u_uart_tx__133_/B1 u_uart_tx__133_/B2 u_uart_tx__133_/Y sky130_fd_sc_hd__o22ai_1
XPHY_EDGE_ROW_0_Left_67 PHY_EDGE_ROW_1_Left_68/VPWR PHY_EDGE_ROW_0_Left_67/VGND PHY_EDGE_ROW_1_Left_68/VPB
+ VSUBS sky130_fd_sc_hd__decap_3
XPHY_EDGE_ROW_36_Left_103 PHY_EDGE_ROW_37_Left_104/VPWR PHY_EDGE_ROW_36_Left_103/VGND
+ PHY_EDGE_ROW_37_Left_104/VPB VSUBS sky130_fd_sc_hd__decap_3
Xu_async_fifo_fifomem__496_ u_async_fifo_fifomem__496_/Q u_async_fifo_fifomem__496_/CLK
+ u_async_fifo_fifomem__496_/D clkbuf_0_s_axi_aclk/VPB VSUBS clkbuf_0_s_axi_aclk/VPB
+ VSUBS sky130_fd_sc_hd__dfxtp_1
Xu_uart_tx__116_ u_uart_tx__153_/VPB VSUBS VSUBS u_uart_tx__153_/VPB u_uart_tx__116_/A
+ u_uart_tx__116_/Y sky130_fd_sc_hd__clkinv_1
XPHY_EDGE_ROW_54_Left_121 PHY_EDGE_ROW_55_Left_122/VPWR PHY_EDGE_ROW_54_Left_121/VGND
+ PHY_EDGE_ROW_55_Left_122/VPB VSUBS sky130_fd_sc_hd__decap_3
XPHY_EDGE_ROW_45_Left_112 PHY_EDGE_ROW_45_Left_112/VPWR PHY_EDGE_ROW_46_Left_113/VGND
+ PHY_EDGE_ROW_45_Left_112/VPB VSUBS sky130_fd_sc_hd__decap_3
XPHY_EDGE_ROW_63_Left_130 PHY_EDGE_ROW_63_Left_130/VPWR PHY_EDGE_ROW_64_Left_131/VGND
+ PHY_EDGE_ROW_63_Left_130/VPB VSUBS sky130_fd_sc_hd__decap_3
Xu_async_fifo_fifomem__350_ VSUBS TAP_TAPCELL_ROW_38_410/VPWR TAP_TAPCELL_ROW_38_410/VPWR
+ VSUBS u_async_fifo_fifomem__350_/X u_async_fifo_fifomem__350_/A1 u_async_fifo_fifomem__350_/S
+ u_async_fifo_fifomem__350_/A0 sky130_fd_sc_hd__mux2_1
Xu_async_fifo_fifomem__281_ VSUBS clkbuf_4_0_0_s_axi_aclk/VPB clkbuf_4_0_0_s_axi_aclk/VPB
+ VSUBS u_async_fifo_fifomem__281_/X u_async_fifo_fifomem__281_/A1 u_async_fifo_fifomem__281_/S
+ u_async_fifo_fifomem__281_/A0 sky130_fd_sc_hd__mux2_1
Xu_async_fifo_wptr_full__36_ TAP_TAPCELL_ROW_15_251/VPWR VSUBS VSUBS TAP_TAPCELL_ROW_15_251/VPWR
+ u_async_fifo_wptr_full__36_/Y u_async_fifo_wptr_full__36_/D u_async_fifo_wptr_full__36_/C
+ u_async_fifo_wptr_full__36_/B u_async_fifo_wptr_full__36_/A sky130_fd_sc_hd__nor4_1
XPHY_EDGE_ROW_3_Left_70 PHY_EDGE_ROW_3_Left_70/VPWR PHY_EDGE_ROW_4_Left_71/VGND PHY_EDGE_ROW_3_Left_70/VPB
+ VSUBS sky130_fd_sc_hd__decap_3
Xu_async_fifo_fifomem__479_ u_async_fifo_fifomem__479_/Q u_async_fifo_fifomem__479_/CLK
+ u_async_fifo_fifomem__479_/D TAP_TAPCELL_ROW_17_262/VPWR VSUBS TAP_TAPCELL_ROW_17_262/VPWR
+ VSUBS sky130_fd_sc_hd__dfxtp_1
Xclkbuf_4_13_0_s_axi_aclk clkbuf_4_13_0_s_axi_aclk/X clkbuf_4_13_0_s_axi_aclk/A clkbuf_4_13_0_s_axi_aclk/VPB
+ VSUBS clkbuf_4_13_0_s_axi_aclk/VGND clkbuf_4_13_0_s_axi_aclk/VPWR sky130_fd_sc_hd__clkbuf_8
Xu_async_fifo_sync_w2r__3_ VSUBS TAP_TAPCELL_ROW_13_238/VPWR TAP_TAPCELL_ROW_13_238/VPWR
+ VSUBS u_async_fifo_sync_w2r__3_/CLK u_async_fifo_sync_w2r__3_/D u_async_fifo_sync_w2r__3_/RESET_B
+ u_async_fifo_sync_w2r__3_/Q sky130_fd_sc_hd__dfrtp_1
Xu_async_fifo_fifomem__195_ VSUBS TAP_TAPCELL_ROW_48_479/VPWR VSUBS TAP_TAPCELL_ROW_48_479/VPWR
+ u_async_fifo_fifomem__205_/S0 u_async_fifo_fifomem__195_/A2 u_async_fifo_fifomem__195_/A3
+ u_async_fifo_fifomem__195_/S1 u_async_fifo_fifomem__195_/A1 u_async_fifo_fifomem__195_/A0
+ u_async_fifo_fifomem__195_/X sky130_fd_sc_hd__mux4_2
Xu_axi_slave__180_ VSUBS u_axi_slave__180_/VPB u_axi_slave__180_/VPB VSUBS u_axi_slave__180_/X
+ u_axi_slave__180_/A1 u_axi_slave__180_/S u_axi_slave__180_/A0 sky130_fd_sc_hd__mux2_1
Xu_async_fifo_fifomem__402_ u_async_fifo_fifomem__402_/Q u_async_fifo_fifomem__402_/CLK
+ u_async_fifo_fifomem__402_/D load_slew1/VPB VSUBS load_slew1/VPB VSUBS sky130_fd_sc_hd__dfxtp_1
Xu_async_fifo_fifomem__264_ VSUBS u_axi_slave__217_/VPB u_axi_slave__217_/VPB VSUBS
+ u_async_fifo_fifomem__264_/X u_async_fifo_fifomem__264_/A1 u_async_fifo_fifomem__264_/S
+ u_async_fifo_fifomem__264_/A0 sky130_fd_sc_hd__mux2_1
Xu_async_fifo_fifomem__333_ TAP_TAPCELL_ROW_23_304/VPWR VSUBS VSUBS TAP_TAPCELL_ROW_23_304/VPWR
+ u_async_fifo_fifomem__333_/C_N u_async_fifo_fifomem__333_/B u_async_fifo_fifomem__333_/Y
+ u_async_fifo_fifomem__333_/A sky130_fd_sc_hd__nor3b_1
Xu_async_fifo_wptr_full__19_ TAP_TAPCELL_ROW_21_293/VPWR VSUBS VSUBS TAP_TAPCELL_ROW_21_293/VPWR
+ u_async_fifo_wptr_full__19_/A u_async_fifo_wptr_full__19_/Y sky130_fd_sc_hd__clkinv_1
Xu_async_fifo_rptr_empty__41_ VSUBS TAP_TAPCELL_ROW_17_265/VPWR TAP_TAPCELL_ROW_17_265/VPWR
+ VSUBS u_async_fifo_rptr_empty__41_/CLK u_async_fifo_rptr_empty__41_/D u_async_fifo_rptr_empty__41_/RESET_B
+ u_async_fifo_rptr_empty__41_/Q sky130_fd_sc_hd__dfrtp_1
Xu_async_fifo_fifomem__316_ VSUBS TAP_TAPCELL_ROW_32_368/VPWR TAP_TAPCELL_ROW_32_368/VPWR
+ VSUBS u_async_fifo_fifomem__316_/X u_async_fifo_fifomem__316_/A1 u_async_fifo_fifomem__316_/S
+ u_async_fifo_fifomem__316_/A0 sky130_fd_sc_hd__mux2_1
Xu_axi_slave__163_ VSUBS u_axi_slave__230_/VPB u_axi_slave__230_/VPB VSUBS u_axi_slave__163_/X
+ u_axi_slave__163_/A1 u_axi_slave__163_/S u_axi_slave__163_/A0 sky130_fd_sc_hd__mux2_1
Xu_axi_slave__232_ VSUBS u_axi_slave__232_/VPB u_axi_slave__232_/VPB VSUBS u_axi_slave__232_/CLK
+ u_axi_slave__232_/D u_axi_slave__232_/RESET_B u_axi_slave__232_/Q sky130_fd_sc_hd__dfrtp_1
Xu_async_fifo_fifomem__247_ TAP_TAPCELL_ROW_23_304/VPWR VSUBS VSUBS TAP_TAPCELL_ROW_23_304/VPWR
+ u_async_fifo_fifomem__247_/Y u_async_fifo_fifomem__247_/B u_async_fifo_fifomem__247_/C
+ u_async_fifo_fifomem__247_/A_N sky130_fd_sc_hd__nand3b_1
Xu_uart_tx__080_ VSUBS u_uart_tx__080_/VPWR u_uart_tx__080_/VPB VSUBS u_uart_tx__080_/X
+ u_uart_tx__080_/A1 u_uart_tx__080_/S u_uart_tx__080_/A0 sky130_fd_sc_hd__mux2_1
Xu_async_fifo_rptr_empty__24_ VSUBS TAP_TAPCELL_ROW_17_265/VPWR VSUBS TAP_TAPCELL_ROW_17_265/VPWR
+ u_async_fifo_rptr_empty__24_/X u_async_fifo_rptr_empty__24_/C u_async_fifo_rptr_empty__24_/B
+ u_async_fifo_rptr_empty__24_/A sky130_fd_sc_hd__xnor3_1
Xu_axi_slave__215_ VSUBS u_axi_slave__215_/VPB u_axi_slave__215_/VPB VSUBS u_axi_slave__215_/CLK
+ u_axi_slave__215_/D u_axi_slave__215_/RESET_B u_axi_slave__215_/Q sky130_fd_sc_hd__dfrtp_1
Xu_axi_slave__146_ u_axi_slave__209_/VPB VSUBS u_axi_slave__209_/VPB VSUBS u_axi_slave__146_/A2
+ u_axi_slave__146_/A1 u_axi_slave__146_/B1 u_axi_slave__146_/Y sky130_fd_sc_hd__a21oi_1
Xu_uart_tx__132_ VSUBS u_uart_tx__132_/VPWR u_uart_tx__132_/B u_uart_tx__132_/Y u_uart_tx__132_/A
+ u_uart_tx__132_/VPB VSUBS sky130_fd_sc_hd__xnor2_1
Xu_axi_slave__129_ u_axi_slave__230_/VPB VSUBS VSUBS u_axi_slave__230_/VPB u_axi_slave__129_/A
+ u_axi_slave__129_/Y u_axi_slave__129_/B sky130_fd_sc_hd__nand2_1
XPHY_EDGE_ROW_21_Right_21 PHY_EDGE_ROW_21_Right_21/VPWR PHY_EDGE_ROW_22_Right_22/VGND
+ PHY_EDGE_ROW_21_Right_21/VPB VSUBS sky130_fd_sc_hd__decap_3
Xu_uart_tx__115_ u_uart_tx__153_/VPB VSUBS u_uart_tx__153_/VPB u_uart_tx__115_/VGND
+ u_uart_tx__115_/A u_uart_tx__115_/C u_uart_tx__115_/D u_uart_tx__115_/Y u_uart_tx__115_/B
+ sky130_fd_sc_hd__nand4_1
XPHY_EDGE_ROW_12_Right_12 TAP_TAPCELL_ROW_13_238/VPWR VSUBS TAP_TAPCELL_ROW_13_238/VPWR
+ VSUBS sky130_fd_sc_hd__decap_3
Xu_async_fifo_fifomem__495_ u_async_fifo_fifomem__495_/Q u_async_fifo_fifomem__495_/CLK
+ u_async_fifo_fifomem__495_/D TAP_TAPCELL_ROW_17_262/VPWR VSUBS TAP_TAPCELL_ROW_17_262/VPWR
+ VSUBS sky130_fd_sc_hd__dfxtp_1
XPHY_EDGE_ROW_30_Right_30 PHY_EDGE_ROW_31_Right_31/VPWR PHY_EDGE_ROW_30_Right_30/VGND
+ PHY_EDGE_ROW_31_Right_31/VPB VSUBS sky130_fd_sc_hd__decap_3
Xu_async_fifo_fifomem__280_ u_async_fifo_fifomem__280_/VGND u_async_fifo_fifomem__420_/VPWR
+ u_async_fifo_fifomem__420_/VPB VSUBS u_async_fifo_fifomem__280_/X u_async_fifo_fifomem__280_/A1
+ u_async_fifo_fifomem__280_/S u_async_fifo_fifomem__280_/A0 sky130_fd_sc_hd__mux2_1
Xu_async_fifo_wptr_full__35_ TAP_TAPCELL_ROW_19_279/VPWR VSUBS VSUBS TAP_TAPCELL_ROW_19_279/VPWR
+ u_async_fifo_wptr_full__35_/A_N u_async_fifo_wptr_full__35_/B u_async_fifo_wptr_full__35_/Y
+ sky130_fd_sc_hd__nand2b_1
Xu_async_fifo_fifomem__478_ u_async_fifo_fifomem__478_/Q u_async_fifo_fifomem__478_/CLK
+ u_async_fifo_fifomem__478_/D TAP_TAPCELL_ROW_51_500/VPWR VSUBS TAP_TAPCELL_ROW_51_500/VPWR
+ u_async_fifo_fifomem__478_/VGND sky130_fd_sc_hd__dfxtp_1
Xu_async_fifo_sync_w2r__2_ VSUBS TAP_TAPCELL_ROW_17_266/VPWR TAP_TAPCELL_ROW_17_266/VPWR
+ VSUBS u_async_fifo_sync_w2r__2_/CLK u_async_fifo_sync_w2r__2_/D u_async_fifo_sync_w2r__2_/RESET_B
+ u_async_fifo_sync_w2r__2_/Q sky130_fd_sc_hd__dfrtp_1
Xu_async_fifo_fifomem__263_ VSUBS u_async_fifo_fifomem__263_/VPWR u_async_fifo_fifomem__263_/VPB
+ VSUBS u_async_fifo_fifomem__263_/X u_async_fifo_fifomem__263_/A1 u_async_fifo_fifomem__263_/S
+ u_async_fifo_fifomem__263_/A0 sky130_fd_sc_hd__mux2_1
Xu_async_fifo_fifomem__332_ VSUBS TAP_TAPCELL_ROW_44_450/VPWR TAP_TAPCELL_ROW_44_450/VPWR
+ VSUBS u_async_fifo_fifomem__332_/X u_async_fifo_fifomem__332_/A1 u_async_fifo_fifomem__332_/S
+ u_async_fifo_fifomem__332_/A0 sky130_fd_sc_hd__mux2_1
Xu_async_fifo_fifomem__401_ u_async_fifo_fifomem__401_/Q u_async_fifo_fifomem__401_/CLK
+ u_async_fifo_fifomem__401_/D TAP_TAPCELL_ROW_41_431/VPWR VSUBS TAP_TAPCELL_ROW_41_431/VPWR
+ VSUBS sky130_fd_sc_hd__dfxtp_1
Xu_async_fifo_fifomem__194_ VSUBS TAP_TAPCELL_ROW_37_403/VPWR VSUBS TAP_TAPCELL_ROW_37_403/VPWR
+ u_async_fifo_fifomem__194_/S0 u_async_fifo_fifomem__194_/A2 u_async_fifo_fifomem__194_/A3
+ u_async_fifo_fifomem__194_/S1 u_async_fifo_fifomem__194_/A1 u_async_fifo_fifomem__194_/A0
+ u_async_fifo_fifomem__194_/X sky130_fd_sc_hd__mux4_2
Xu_async_fifo_wptr_full__18_ VSUBS u_axi_slave__217_/VPB u_axi_slave__217_/VPB VSUBS
+ u_async_fifo_wptr_full__18_/A u_async_fifo_wptr_full__18_/X u_async_fifo_wptr_full__18_/B
+ sky130_fd_sc_hd__xor2_1
Xu_async_fifo_rptr_empty__40_ VSUBS TAP_TAPCELL_ROW_9_208/VPWR TAP_TAPCELL_ROW_9_208/VPWR
+ VSUBS u_async_fifo_rptr_empty__40_/CLK u_async_fifo_rptr_empty__40_/D u_async_fifo_rptr_empty__40_/RESET_B
+ u_async_fifo_rptr_empty__40_/Q sky130_fd_sc_hd__dfrtp_1
XPHY_EDGE_ROW_6_Right_6 PHY_EDGE_ROW_7_Right_7/VPWR PHY_EDGE_ROW_6_Right_6/VGND PHY_EDGE_ROW_7_Right_7/VPB
+ VSUBS sky130_fd_sc_hd__decap_3
XPHY_EDGE_ROW_59_Right_59 PHY_EDGE_ROW_59_Right_59/VPWR PHY_EDGE_ROW_60_Right_60/VGND
+ PHY_EDGE_ROW_59_Right_59/VPB VSUBS sky130_fd_sc_hd__decap_3
Xu_axi_slave__231_ VSUBS u_axi_slave__231_/VPB u_axi_slave__231_/VPB VSUBS u_axi_slave__231_/CLK
+ u_axi_slave__231_/D u_axi_slave__231_/RESET_B u_axi_slave__231_/Q sky130_fd_sc_hd__dfrtp_1
Xu_axi_slave__162_ VSUBS u_axi_slave__236_/VPB u_axi_slave__236_/VPB VSUBS u_axi_slave__162_/X
+ u_axi_slave__162_/A1 u_axi_slave__162_/S u_axi_slave__162_/A0 sky130_fd_sc_hd__mux2_1
Xu_async_fifo_fifomem__315_ u_async_fifo_fifomem__315_/VPB VSUBS VSUBS u_async_fifo_fifomem__315_/VPWR
+ u_async_fifo_fifomem__315_/A u_async_fifo_fifomem__315_/B u_async_fifo_fifomem__315_/Y
+ sky130_fd_sc_hd__nor2_1
Xu_async_fifo_fifomem__246_ u_async_fifo_fifomem__369_/VPB VSUBS VSUBS u_async_fifo_fifomem__369_/VPWR
+ u_async_fifo_fifomem__246_/A u_async_fifo_fifomem__246_/B u_async_fifo_fifomem__246_/Y
+ sky130_fd_sc_hd__nor2_1
Xu_async_fifo_rptr_empty__23_ VSUBS clkbuf_3_6__f_uart_clk/VPB u_async_fifo_rptr_empty__23_/B
+ u_async_fifo_rptr_empty__23_/Y u_async_fifo_rptr_empty__23_/A clkbuf_3_6__f_uart_clk/VPB
+ VSUBS sky130_fd_sc_hd__xnor2_1
Xu_async_fifo_fifomem__229_ VSUBS TAP_TAPCELL_ROW_46_465/VPWR TAP_TAPCELL_ROW_46_465/VPWR
+ VSUBS u_async_fifo_fifomem__229_/X u_async_fifo_fifomem__229_/A1 u_async_fifo_fifomem__229_/S
+ u_async_fifo_fifomem__229_/A0 sky130_fd_sc_hd__mux2_1
Xu_axi_slave__145_ VSUBS ANTENNA_1/VPB u_axi_slave__145_/X u_axi_slave__145_/B u_axi_slave__145_/A
+ u_axi_slave__145_/C ANTENNA_1/VPB VSUBS sky130_fd_sc_hd__and3_1
Xu_axi_slave__214_ VSUBS u_async_fifo__1_/VPB u_async_fifo__1_/VPB VSUBS u_axi_slave__214_/CLK
+ u_axi_slave__214_/D u_axi_slave__214_/RESET_B u_axi_slave__214_/Q sky130_fd_sc_hd__dfrtp_1
Xu_uart_tx__131_ u_uart_tx__166_/VPB VSUBS VSUBS u_uart_tx__166_/VPB u_uart_tx__131_/A1
+ u_uart_tx__131_/A2 u_uart_tx__131_/B1 u_uart_tx__131_/B2 u_uart_tx__131_/Y sky130_fd_sc_hd__o22ai_1
Xu_axi_slave__128_ VSUBS u_axi_slave__227_/VPB u_axi_slave__227_/VPB VSUBS u_axi_slave__128_/A3
+ u_axi_slave__128_/A2 u_axi_slave__128_/A1 u_axi_slave__128_/Y u_axi_slave__128_/B1
+ sky130_fd_sc_hd__a31oi_1
Xu_uart_tx__114_ u_uart_tx__152_/VPB VSUBS u_uart_tx__152_/VPB VSUBS u_uart_tx__114_/A2
+ u_uart_tx__114_/A1 u_uart_tx__114_/B1 u_uart_tx__114_/Y sky130_fd_sc_hd__a21oi_1
Xu_async_fifo_fifomem__494_ u_async_fifo_fifomem__494_/Q u_async_fifo_fifomem__494_/CLK
+ u_async_fifo_fifomem__494_/D TAP_TAPCELL_ROW_49_486/VPWR VSUBS TAP_TAPCELL_ROW_49_486/VPWR
+ VSUBS sky130_fd_sc_hd__dfxtp_1
Xu_async_fifo_wptr_full__34_ VSUBS clkbuf_3_6__f_uart_clk/VPB u_async_fifo_wptr_full__34_/B
+ u_async_fifo_wptr_full__34_/Y u_async_fifo_wptr_full__34_/A clkbuf_3_6__f_uart_clk/VPB
+ VSUBS sky130_fd_sc_hd__xnor2_1
Xu_async_fifo_fifomem__477_ u_async_fifo_fifomem__477_/Q u_async_fifo_fifomem__477_/CLK
+ u_async_fifo_fifomem__477_/D _38_/VPB VSUBS _38_/VPB VSUBS sky130_fd_sc_hd__dfxtp_1
Xu_async_fifo_sync_w2r__1_ VSUBS clkbuf_0_uart_clk/VPB clkbuf_0_uart_clk/VPB VSUBS
+ u_async_fifo_sync_w2r__1_/CLK u_async_fifo_sync_w2r__1_/D u_async_fifo_sync_w2r__1_/RESET_B
+ u_async_fifo_sync_w2r__1_/Q sky130_fd_sc_hd__dfrtp_1
Xu_async_fifo_fifomem__193_ VSUBS TAP_TAPCELL_ROW_37_403/VPWR VSUBS TAP_TAPCELL_ROW_37_403/VPWR
+ u_async_fifo_fifomem__193_/S0 u_async_fifo_fifomem__193_/A2 u_async_fifo_fifomem__193_/A3
+ u_async_fifo_fifomem__193_/S1 u_async_fifo_fifomem__193_/A1 u_async_fifo_fifomem__193_/A0
+ u_async_fifo_fifomem__193_/X sky130_fd_sc_hd__mux4_2
Xu_async_fifo_fifomem__400_ u_async_fifo_fifomem__400_/Q u_async_fifo_fifomem__400_/CLK
+ u_async_fifo_fifomem__400_/D clkbuf_0_s_axi_aclk/VPB VSUBS clkbuf_0_s_axi_aclk/VPB
+ VSUBS sky130_fd_sc_hd__dfxtp_1
Xu_async_fifo_fifomem__331_ VSUBS TAP_TAPCELL_ROW_31_359/VPWR TAP_TAPCELL_ROW_31_359/VPWR
+ VSUBS u_async_fifo_fifomem__331_/X u_async_fifo_fifomem__331_/A1 u_async_fifo_fifomem__331_/S
+ u_async_fifo_fifomem__331_/A0 sky130_fd_sc_hd__mux2_1
Xu_async_fifo_fifomem__262_ VSUBS clkbuf_4_9_0_s_axi_aclk/VPB clkbuf_4_9_0_s_axi_aclk/VPB
+ VSUBS u_async_fifo_fifomem__262_/X u_async_fifo_fifomem__262_/A1 u_async_fifo_fifomem__262_/S
+ u_async_fifo_fifomem__262_/A0 sky130_fd_sc_hd__mux2_1
Xu_async_fifo_wptr_full__17_ VSUBS u_axi_slave__217_/VPB u_async_fifo_wptr_full__17_/C
+ u_async_fifo_wptr_full__17_/A_N u_async_fifo_wptr_full__17_/X u_async_fifo_wptr_full__17_/D
+ u_async_fifo_wptr_full__17_/B u_axi_slave__217_/VPB VSUBS sky130_fd_sc_hd__and4b_1
Xu_async_fifo_fifomem__314_ VSUBS u_async_fifo_fifomem__449_/VPWR u_async_fifo_fifomem__449_/VPB
+ VSUBS u_async_fifo_fifomem__314_/X u_async_fifo_fifomem__314_/A1 u_async_fifo_fifomem__314_/S
+ u_async_fifo_fifomem__314_/A0 sky130_fd_sc_hd__mux2_1
Xu_axi_slave__161_ VSUBS u_axi_slave__210_/VPB u_axi_slave__210_/VPB VSUBS u_axi_slave__161_/X
+ u_axi_slave__161_/A1 u_axi_slave__161_/S u_axi_slave__161_/A0 sky130_fd_sc_hd__mux2_1
Xu_async_fifo_fifomem__245_ VSUBS TAP_TAPCELL_ROW_40_422/VPWR TAP_TAPCELL_ROW_40_422/VPWR
+ VSUBS u_async_fifo_fifomem__245_/X u_async_fifo_fifomem__245_/A1 u_async_fifo_fifomem__245_/S
+ u_async_fifo_fifomem__245_/A0 sky130_fd_sc_hd__mux2_1
Xu_axi_slave__230_ VSUBS u_axi_slave__230_/VPB u_axi_slave__230_/VPB VSUBS u_axi_slave__230_/CLK
+ u_axi_slave__230_/D u_axi_slave__230_/RESET_B u_axi_slave__230_/Q sky130_fd_sc_hd__dfrtp_1
Xu_async_fifo_rptr_empty__22_ TAP_TAPCELL_ROW_12_229/VPWR VSUBS TAP_TAPCELL_ROW_12_229/VPWR
+ VSUBS u_async_fifo_rptr_empty__22_/A2 u_async_fifo_rptr_empty__22_/A1 u_async_fifo_rptr_empty__22_/B1
+ u_async_fifo_rptr_empty__22_/Y sky130_fd_sc_hd__a21oi_1
Xu_axi_slave__213_ VSUBS u_axi_slave__244_/VPB u_axi_slave__244_/VPB VSUBS u_axi_slave__213_/CLK
+ u_axi_slave__213_/D u_axi_slave__213_/RESET_B u_axi_slave__213_/Q sky130_fd_sc_hd__dfrtp_1
Xu_async_fifo_fifomem__228_ u_async_fifo_fifomem__379_/VGND u_async_fifo_fifomem__228_/VPWR
+ u_async_fifo_fifomem__228_/VPB VSUBS u_async_fifo_fifomem__228_/X u_async_fifo_fifomem__228_/A1
+ u_async_fifo_fifomem__228_/S u_async_fifo_fifomem__228_/A0 sky130_fd_sc_hd__mux2_1
Xu_axi_slave__144_ u_axi_slave__231_/VPB VSUBS u_axi_slave__231_/VPB VSUBS u_axi_slave__144_/B2
+ u_axi_slave__144_/B1 u_axi_slave__144_/Y u_axi_slave__144_/A1 u_axi_slave__144_/A2
+ sky130_fd_sc_hd__a22oi_1
Xu_uart_tx__130_ VSUBS u_uart_tx__166_/VPB u_uart_tx__130_/B u_uart_tx__130_/Y u_uart_tx__130_/A
+ u_uart_tx__166_/VPB VSUBS sky130_fd_sc_hd__xnor2_1
XPHY_EDGE_ROW_19_Left_86 PHY_EDGE_ROW_19_Left_86/VPWR PHY_EDGE_ROW_20_Left_87/VGND
+ PHY_EDGE_ROW_19_Left_86/VPB VSUBS sky130_fd_sc_hd__decap_3
Xu_axi_slave__127_ VSUBS u_axi_slave__227_/VPB u_axi_slave__227_/VPB VSUBS u_axi_slave__127_/Y
+ u_axi_slave__127_/B1 u_axi_slave__127_/C1 u_axi_slave__127_/A1 u_axi_slave__127_/A2
+ u_axi_slave__127_/B2 sky130_fd_sc_hd__a221oi_1
Xu_uart_tx__113_ u_uart_tx__113_/VPB VSUBS VSUBS u_uart_tx__113_/VPWR u_uart_tx__113_/A
+ u_uart_tx__113_/B u_uart_tx__113_/Y sky130_fd_sc_hd__nor2_1
Xu_async_fifo_fifomem__493_ u_async_fifo_fifomem__493_/Q u_async_fifo_fifomem__493_/CLK
+ u_async_fifo_fifomem__493_/D u_async_fifo_fifomem__493_/VPB VSUBS u_async_fifo_fifomem__493_/VPWR
+ VSUBS sky130_fd_sc_hd__dfxtp_1
Xclkbuf_4_4_0_s_axi_aclk clkbuf_4_4_0_s_axi_aclk/X clkbuf_4_4_0_s_axi_aclk/A clkbuf_4_4_0_s_axi_aclk/VPB
+ VSUBS VSUBS clkbuf_4_4_0_s_axi_aclk/VPB sky130_fd_sc_hd__clkbuf_8
Xu_async_fifo_wptr_full__33_ VSUBS clkbuf_3_6__f_uart_clk/VPB u_async_fifo_wptr_full__33_/B
+ u_async_fifo_wptr_full__33_/Y u_async_fifo_wptr_full__33_/A clkbuf_3_6__f_uart_clk/VPB
+ VSUBS sky130_fd_sc_hd__xnor2_1
Xu_async_fifo_fifomem__476_ u_async_fifo_fifomem__476_/Q u_async_fifo_fifomem__476_/CLK
+ u_async_fifo_fifomem__476_/D TAP_TAPCELL_ROW_51_500/VPWR VSUBS TAP_TAPCELL_ROW_51_500/VPWR
+ VSUBS sky130_fd_sc_hd__dfxtp_1
Xu_async_fifo_sync_w2r__0_ VSUBS TAP_TAPCELL_ROW_21_292/VPWR TAP_TAPCELL_ROW_21_292/VPWR
+ VSUBS u_async_fifo_sync_w2r__0_/CLK u_async_fifo_sync_w2r__0_/D u_async_fifo_sync_w2r__0_/RESET_B
+ u_async_fifo_sync_w2r__0_/Q sky130_fd_sc_hd__dfrtp_1
Xu_async_fifo_fifomem__261_ VSUBS TAP_TAPCELL_ROW_47_474/VPWR TAP_TAPCELL_ROW_47_474/VPWR
+ VSUBS u_async_fifo_fifomem__261_/X u_async_fifo_fifomem__261_/A1 u_async_fifo_fifomem__261_/S
+ u_async_fifo_fifomem__261_/A0 sky130_fd_sc_hd__mux2_1
Xu_async_fifo_fifomem__192_ VSUBS TAP_TAPCELL_ROW_37_403/VPWR VSUBS TAP_TAPCELL_ROW_37_403/VPWR
+ u_async_fifo_fifomem__192_/S0 u_async_fifo_fifomem__192_/A2 u_async_fifo_fifomem__192_/A3
+ u_async_fifo_fifomem__192_/S1 u_async_fifo_fifomem__192_/A1 u_async_fifo_fifomem__192_/A0
+ u_async_fifo_fifomem__192_/X sky130_fd_sc_hd__mux4_2
Xu_async_fifo_wptr_full__16_ u_axi_slave__217_/VPB VSUBS VSUBS u_axi_slave__217_/VPB
+ u_async_fifo_wptr_full__16_/Y u_async_fifo_wptr_full__16_/B u_async_fifo_wptr_full__16_/C
+ u_async_fifo_wptr_full__16_/A_N sky130_fd_sc_hd__nand3b_1
Xu_async_fifo_fifomem__330_ VSUBS TAP_TAPCELL_ROW_23_303/VPWR TAP_TAPCELL_ROW_23_303/VPWR
+ VSUBS u_async_fifo_fifomem__330_/X u_async_fifo_fifomem__330_/A1 u_async_fifo_fifomem__330_/S
+ u_async_fifo_fifomem__330_/A0 sky130_fd_sc_hd__mux2_1
X_29_ VSUBS _29_/VPB _29_/VPB VSUBS _29_/CLK _29_/D _35_/RESET_B _29_/Q sky130_fd_sc_hd__dfrtp_1
Xu_async_fifo_fifomem__459_ u_async_fifo_fifomem__459_/Q u_async_fifo_fifomem__459_/CLK
+ u_async_fifo_fifomem__459_/D u_async_fifo_fifomem__459_/VPB VSUBS u_async_fifo_fifomem__459_/VPWR
+ VSUBS sky130_fd_sc_hd__dfxtp_1
Xu_async_fifo__1_ u_async_fifo__1_/VPB VSUBS VSUBS u_async_fifo__1_/VPB u_async_fifo__1_/A
+ u_async_fifo__1_/SLEEP u_async_fifo__1_/X sky130_fd_sc_hd__lpflow_isobufsrc_1
XPHY_EDGE_ROW_7_Left_74 PHY_EDGE_ROW_7_Left_74/VPWR PHY_EDGE_ROW_8_Left_75/VGND PHY_EDGE_ROW_7_Left_74/VPB
+ VSUBS sky130_fd_sc_hd__decap_3
Xu_axi_slave__160_ VSUBS u_axi_slave__209_/VPB u_axi_slave__209_/VPB VSUBS u_axi_slave__160_/X
+ u_axi_slave__160_/A1 u_axi_slave__160_/S u_axi_slave__160_/A0 sky130_fd_sc_hd__mux2_1
Xu_async_fifo_fifomem__313_ VSUBS TAP_TAPCELL_ROW_35_387/VPWR TAP_TAPCELL_ROW_35_387/VPWR
+ VSUBS u_async_fifo_fifomem__313_/X u_async_fifo_fifomem__313_/A1 u_async_fifo_fifomem__313_/S
+ u_async_fifo_fifomem__313_/A0 sky130_fd_sc_hd__mux2_1
Xu_async_fifo_fifomem__244_ VSUBS TAP_TAPCELL_ROW_33_374/VPWR TAP_TAPCELL_ROW_33_374/VPWR
+ VSUBS u_async_fifo_fifomem__244_/X u_async_fifo_fifomem__244_/A1 u_async_fifo_fifomem__244_/S
+ u_async_fifo_fifomem__244_/A0 sky130_fd_sc_hd__mux2_1
Xu_async_fifo_rptr_empty__21_ VSUBS TAP_TAPCELL_ROW_17_265/VPWR u_async_fifo_rptr_empty__21_/B
+ u_async_fifo_rptr_empty__21_/Y u_async_fifo_rptr_empty__21_/A TAP_TAPCELL_ROW_17_265/VPWR
+ VSUBS sky130_fd_sc_hd__xnor2_1
Xu_async_fifo_fifomem__227_ VSUBS TAP_TAPCELL_ROW_31_359/VPWR TAP_TAPCELL_ROW_31_359/VPWR
+ VSUBS u_async_fifo_fifomem__227_/X u_async_fifo_fifomem__227_/A1 u_async_fifo_fifomem__227_/S
+ u_async_fifo_fifomem__227_/A0 sky130_fd_sc_hd__mux2_1
Xu_axi_slave__212_ VSUBS u_axi_slave__230_/VPB u_axi_slave__230_/VPB VSUBS u_axi_slave__212_/CLK
+ u_axi_slave__212_/D u_axi_slave__230_/RESET_B u_axi_slave__212_/Q sky130_fd_sc_hd__dfrtp_1
Xu_axi_slave__143_ VSUBS u_axi_slave__230_/VPB u_axi_slave__230_/VPB VSUBS u_axi_slave__143_/A3
+ u_axi_slave__143_/A2 u_axi_slave__143_/A1 u_axi_slave__143_/Y u_axi_slave__143_/B1
+ sky130_fd_sc_hd__a31oi_1
Xclkbuf_4_9_0_s_axi_aclk clkbuf_4_9_0_s_axi_aclk/X clkbuf_4_9_0_s_axi_aclk/A clkbuf_4_9_0_s_axi_aclk/VPB
+ VSUBS VSUBS clkbuf_4_9_0_s_axi_aclk/VPB sky130_fd_sc_hd__clkbuf_8
Xu_axi_slave__126_ u_axi_slave__227_/VPB VSUBS VSUBS u_axi_slave__227_/VPB u_axi_slave__126_/A
+ u_axi_slave__126_/B u_axi_slave__126_/Y sky130_fd_sc_hd__nor2_1
XPHY_EDGE_ROW_20_Left_87 PHY_EDGE_ROW_21_Left_88/VPWR PHY_EDGE_ROW_20_Left_87/VGND
+ PHY_EDGE_ROW_21_Left_88/VPB VSUBS sky130_fd_sc_hd__decap_3
Xu_uart_tx__112_ VSUBS u_uart_tx__113_/VPWR u_uart_tx__112_/B u_uart_tx__112_/Y u_uart_tx__112_/A
+ u_uart_tx__113_/VPB VSUBS sky130_fd_sc_hd__xnor2_1
Xu_async_fifo_fifomem__492_ u_async_fifo_fifomem__492_/Q u_async_fifo_fifomem__492_/CLK
+ u_async_fifo_fifomem__492_/D u_async_fifo_fifomem__492_/VPB VSUBS u_async_fifo_fifomem__492_/VPWR
+ u_async_fifo_fifomem__492_/VGND sky130_fd_sc_hd__dfxtp_1
Xu_axi_slave__109_ ANTENNA_2/VPB VSUBS VSUBS ANTENNA_2/VPB u_axi_slave__109_/A u_axi_slave__109_/B
+ u_axi_slave__109_/Y sky130_fd_sc_hd__nor2_1
Xu_async_fifo_wptr_full__32_ VSUBS clkbuf_3_6__f_uart_clk/VPB clkbuf_3_6__f_uart_clk/VPB
+ VSUBS u_async_fifo_wptr_full__32_/A u_async_fifo_wptr_full__32_/X u_async_fifo_wptr_full__32_/B
+ sky130_fd_sc_hd__xor2_1
Xu_async_fifo_fifomem__475_ u_async_fifo_fifomem__475_/Q u_async_fifo_fifomem__475_/CLK
+ u_async_fifo_fifomem__475_/D TAP_TAPCELL_ROW_35_388/VPWR VSUBS TAP_TAPCELL_ROW_35_388/VPWR
+ VSUBS sky130_fd_sc_hd__dfxtp_1
Xu_async_fifo_fifomem__260_ clkbuf_4_13_0_s_axi_aclk/VGND u_axi_slave__199_/VPB u_axi_slave__199_/VPB
+ VSUBS u_async_fifo_fifomem__260_/X u_async_fifo_fifomem__260_/A1 u_async_fifo_fifomem__260_/S
+ u_async_fifo_fifomem__260_/A0 sky130_fd_sc_hd__mux2_1
XPHY_EDGE_ROW_23_Left_90 PHY_EDGE_ROW_23_Left_90/VPWR PHY_EDGE_ROW_24_Left_91/VGND
+ PHY_EDGE_ROW_23_Left_90/VPB VSUBS sky130_fd_sc_hd__decap_3
Xu_async_fifo_wptr_full__15_ u_axi_slave__217_/VPB VSUBS VSUBS u_axi_slave__217_/VPB
+ u_async_fifo_wptr_full__15_/A_N u_async_fifo_wptr_full__15_/B u_async_fifo_wptr_full__15_/Y
+ sky130_fd_sc_hd__nand2b_1
X_28_ _28_/VPB VSUBS _28_/VPB VSUBS _28_/Q _28_/SET_B _28_/D _28_/CLK sky130_fd_sc_hd__dfstp_2
XPHY_EDGE_ROW_51_Left_118 PHY_EDGE_ROW_51_Left_118/VPWR PHY_EDGE_ROW_52_Left_119/VGND
+ PHY_EDGE_ROW_51_Left_118/VPB VSUBS sky130_fd_sc_hd__decap_3
XPHY_EDGE_ROW_42_Left_109 PHY_EDGE_ROW_43_Left_110/VPWR PHY_EDGE_ROW_42_Left_109/VGND
+ PHY_EDGE_ROW_43_Left_110/VPB VSUBS sky130_fd_sc_hd__decap_3
Xu_async_fifo_fifomem__191_ VSUBS TAP_TAPCELL_ROW_37_402/VPWR VSUBS TAP_TAPCELL_ROW_37_402/VPWR
+ u_async_fifo_fifomem__191_/S0 u_async_fifo_fifomem__191_/A2 u_async_fifo_fifomem__191_/A3
+ u_async_fifo_fifomem__191_/S1 u_async_fifo_fifomem__191_/A1 u_async_fifo_fifomem__191_/A0
+ u_async_fifo_fifomem__191_/X sky130_fd_sc_hd__mux4_2
Xu_async_fifo_fifomem__458_ u_async_fifo_fifomem__458_/Q u_async_fifo_fifomem__458_/CLK
+ u_async_fifo_fifomem__458_/D clkbuf_4_1_0_s_axi_aclk/VPB VSUBS clkbuf_4_1_0_s_axi_aclk/VPB
+ VSUBS sky130_fd_sc_hd__dfxtp_1
Xu_async_fifo_fifomem__389_ u_async_fifo_fifomem__389_/Q u_async_fifo_fifomem__389_/CLK
+ u_async_fifo_fifomem__389_/D u_async_fifo_fifomem__389_/VPB VSUBS u_async_fifo_fifomem__389_/VPWR
+ u_async_fifo_fifomem__389_/VGND sky130_fd_sc_hd__dfxtp_1
XPHY_EDGE_ROW_60_Left_127 PHY_EDGE_ROW_61_Left_128/VPWR PHY_EDGE_ROW_60_Left_127/VGND
+ PHY_EDGE_ROW_61_Left_128/VPB VSUBS sky130_fd_sc_hd__decap_3
Xu_async_fifo_fifomem__312_ VSUBS TAP_TAPCELL_ROW_23_303/VPWR TAP_TAPCELL_ROW_23_303/VPWR
+ VSUBS u_async_fifo_fifomem__312_/X u_async_fifo_fifomem__312_/A1 u_async_fifo_fifomem__312_/S
+ u_async_fifo_fifomem__312_/A0 sky130_fd_sc_hd__mux2_1
Xu_async_fifo_fifomem__243_ VSUBS TAP_TAPCELL_ROW_20_282/VPWR TAP_TAPCELL_ROW_20_282/VPWR
+ VSUBS u_async_fifo_fifomem__243_/X u_async_fifo_fifomem__243_/A1 u_async_fifo_fifomem__243_/S
+ u_async_fifo_fifomem__243_/A0 sky130_fd_sc_hd__mux2_1
XPHY_EDGE_ROW_28_Right_28 PHY_EDGE_ROW_29_Right_29/VPWR PHY_EDGE_ROW_28_Right_28/VGND
+ PHY_EDGE_ROW_29_Right_29/VPB VSUBS sky130_fd_sc_hd__decap_3
XPHY_EDGE_ROW_19_Right_19 PHY_EDGE_ROW_19_Right_19/VPWR PHY_EDGE_ROW_20_Right_20/VGND
+ PHY_EDGE_ROW_19_Right_19/VPB VSUBS sky130_fd_sc_hd__decap_3
Xu_async_fifo_rptr_empty__20_ clkbuf_3_3__f_uart_clk/VPB VSUBS u_async_fifo_rptr_empty__31_/VGND
+ clkbuf_3_3__f_uart_clk/VPB u_async_fifo_rptr_empty__20_/A u_async_fifo_rptr_empty__20_/B
+ u_async_fifo_rptr_empty__20_/Y sky130_fd_sc_hd__nor2_1
XPHY_EDGE_ROW_55_Right_55 PHY_EDGE_ROW_55_Right_55/VPWR PHY_EDGE_ROW_56_Right_56/VGND
+ PHY_EDGE_ROW_55_Right_55/VPB VSUBS sky130_fd_sc_hd__decap_3
XPHY_EDGE_ROW_46_Right_46 u_axi_slave__242_/VPB VSUBS u_axi_slave__242_/VPB VSUBS
+ sky130_fd_sc_hd__decap_3
XPHY_EDGE_ROW_37_Right_37 PHY_EDGE_ROW_37_Right_37/VPWR PHY_EDGE_ROW_38_Right_38/VGND
+ PHY_EDGE_ROW_37_Right_37/VPB VSUBS sky130_fd_sc_hd__decap_3
XPHY_EDGE_ROW_64_Right_64 PHY_EDGE_ROW_65_Right_65/VPWR PHY_EDGE_ROW_64_Right_64/VGND
+ PHY_EDGE_ROW_65_Right_65/VPB VSUBS sky130_fd_sc_hd__decap_3
Xu_axi_slave__142_ VSUBS u_axi_slave__220_/VPB u_axi_slave__220_/VPB VSUBS u_axi_slave__142_/Y
+ u_axi_slave__142_/B1 u_axi_slave__142_/C1 u_axi_slave__142_/A1 u_axi_slave__142_/A2
+ u_axi_slave__142_/B2 sky130_fd_sc_hd__a221oi_1
Xu_axi_slave__211_ VSUBS u_axi_slave__211_/VPB u_axi_slave__211_/VPB VSUBS u_axi_slave__211_/CLK
+ u_axi_slave__211_/D u_axi_slave__217_/RESET_B u_axi_slave__211_/Q sky130_fd_sc_hd__dfrtp_1
Xu_async_fifo_fifomem__226_ TAP_TAPCELL_ROW_23_304/VPWR VSUBS VSUBS TAP_TAPCELL_ROW_23_304/VPWR
+ u_async_fifo_fifomem__226_/C_N u_async_fifo_fifomem__226_/B u_async_fifo_fifomem__226_/Y
+ u_async_fifo_fifomem__226_/A sky130_fd_sc_hd__nor3b_1
Xu_async_fifo_fifomem__209_ VSUBS TAP_TAPCELL_ROW_47_472/VPWR VSUBS TAP_TAPCELL_ROW_47_472/VPWR
+ u_async_fifo_fifomem__209_/S0 u_async_fifo_fifomem__209_/A2 u_async_fifo_fifomem__209_/A3
+ u_async_fifo_fifomem__209_/S1 u_async_fifo_fifomem__209_/A1 u_async_fifo_fifomem__209_/A0
+ u_async_fifo_fifomem__209_/X sky130_fd_sc_hd__mux4_2
Xu_axi_slave__125_ u_axi_slave__227_/VPB VSUBS VSUBS u_axi_slave__227_/VPB u_axi_slave__125_/A
+ u_axi_slave__125_/B u_axi_slave__125_/Y u_axi_slave__125_/C sky130_fd_sc_hd__nand3_1
Xu_uart_tx__111_ u_uart_tx__152_/VPB VSUBS VSUBS u_uart_tx__152_/VPB u_uart_tx__111_/C
+ u_uart_tx__111_/B u_uart_tx__111_/A u_uart_tx__111_/Y sky130_fd_sc_hd__nor3_1
Xu_async_fifo_fifomem__491_ u_async_fifo_fifomem__491_/Q u_async_fifo_fifomem__491_/CLK
+ u_async_fifo_fifomem__491_/D u_async_fifo_fifomem__491_/VPB VSUBS u_async_fifo_fifomem__491_/VPWR
+ u_async_fifo_fifomem__491_/VGND sky130_fd_sc_hd__dfxtp_1
Xu_axi_slave__108_ u_axi_slave__159_/VPB VSUBS VSUBS u_axi_slave__159_/VPB u_axi_slave__108_/A
+ u_axi_slave__108_/Y u_axi_slave__108_/B sky130_fd_sc_hd__nand2_1
Xu_async_fifo_wptr_full__31_ VSUBS TAP_TAPCELL_ROW_21_293/VPWR TAP_TAPCELL_ROW_21_293/VPWR
+ VSUBS u_async_fifo_wptr_full__31_/X u_async_fifo_wptr_full__31_/A1 u_async_fifo_wptr_full__31_/S
+ u_async_fifo_wptr_full__31_/A0 sky130_fd_sc_hd__mux2_1
Xu_async_fifo_fifomem__474_ u_async_fifo_fifomem__474_/Q u_async_fifo_fifomem__474_/CLK
+ u_async_fifo_fifomem__474_/D u_async_fifo_fifomem__474_/VPB VSUBS u_async_fifo_fifomem__474_/VPWR
+ VSUBS sky130_fd_sc_hd__dfxtp_1
Xu_async_fifo_wptr_full__14_ TAP_TAPCELL_ROW_21_293/VPWR VSUBS VSUBS TAP_TAPCELL_ROW_21_293/VPWR
+ u_async_fifo_wptr_full__14_/A u_async_fifo_wptr_full__14_/Y sky130_fd_sc_hd__clkinv_1
X_27_ VSUBS _35_/VPB _35_/VPB VSUBS _27_/X _27_/A1 _27_/S _27_/A0 sky130_fd_sc_hd__mux2_1
Xu_async_fifo_fifomem__190_ VSUBS TAP_TAPCELL_ROW_38_409/VPWR VSUBS TAP_TAPCELL_ROW_38_409/VPWR
+ u_async_fifo_fifomem__190_/S0 u_async_fifo_fifomem__190_/A2 u_async_fifo_fifomem__190_/A3
+ u_async_fifo_fifomem__190_/S1 u_async_fifo_fifomem__190_/A1 u_async_fifo_fifomem__190_/A0
+ u_async_fifo_fifomem__190_/X sky130_fd_sc_hd__mux4_2
Xu_async_fifo_fifomem__457_ u_async_fifo_fifomem__457_/Q u_async_fifo_fifomem__457_/CLK
+ u_async_fifo_fifomem__457_/D TAP_TAPCELL_ROW_43_446/VPWR VSUBS TAP_TAPCELL_ROW_43_446/VPWR
+ VSUBS sky130_fd_sc_hd__dfxtp_1
Xu_async_fifo_fifomem__388_ u_async_fifo_fifomem__388_/Q u_async_fifo_fifomem__388_/CLK
+ u_async_fifo_fifomem__388_/D TAP_TAPCELL_ROW_43_444/VPWR VSUBS TAP_TAPCELL_ROW_43_444/VPWR
+ VSUBS sky130_fd_sc_hd__dfxtp_1
Xu_async_fifo_fifomem__311_ VSUBS u_async_fifo_fifomem__446_/VPWR u_async_fifo_fifomem__446_/VPB
+ VSUBS u_async_fifo_fifomem__311_/X u_async_fifo_fifomem__311_/A1 u_async_fifo_fifomem__311_/S
+ u_async_fifo_fifomem__311_/A0 sky130_fd_sc_hd__mux2_1
Xu_async_fifo_fifomem__242_ VSUBS clkbuf_4_4_0_s_axi_aclk/VPB clkbuf_4_4_0_s_axi_aclk/VPB
+ VSUBS u_async_fifo_fifomem__242_/X u_async_fifo_fifomem__242_/A1 u_async_fifo_fifomem__242_/S
+ u_async_fifo_fifomem__242_/A0 sky130_fd_sc_hd__mux2_1
Xu_axi_slave__210_ VSUBS u_axi_slave__210_/VPB u_axi_slave__210_/VPB VSUBS u_axi_slave__210_/CLK
+ u_axi_slave__210_/D u_axi_slave__210_/RESET_B u_axi_slave__210_/Q sky130_fd_sc_hd__dfrtp_1
Xu_axi_slave__141_ u_axi_slave__141_/VPB VSUBS VSUBS u_axi_slave__141_/VPWR u_axi_slave__141_/A
+ u_axi_slave__141_/B u_axi_slave__141_/Y sky130_fd_sc_hd__nor2_1
Xu_async_fifo_fifomem__225_ TAP_TAPCELL_ROW_23_304/VPWR VSUBS VSUBS TAP_TAPCELL_ROW_23_304/VPWR
+ u_async_fifo_fifomem__225_/Y u_async_fifo_fifomem__225_/B u_async_fifo_fifomem__225_/C
+ u_async_fifo_fifomem__225_/A_N sky130_fd_sc_hd__nand3b_1
Xu_async_fifo_fifomem__208_ VSUBS TAP_TAPCELL_ROW_47_473/VPWR u_async_fifo_fifomem__320_/VGND
+ TAP_TAPCELL_ROW_47_473/VPWR u_async_fifo_fifomem__208_/S0 u_async_fifo_fifomem__208_/A2
+ u_async_fifo_fifomem__208_/A3 u_async_fifo_fifomem__208_/S1 u_async_fifo_fifomem__208_/A1
+ u_async_fifo_fifomem__208_/A0 u_async_fifo_fifomem__208_/X sky130_fd_sc_hd__mux4_2
Xu_axi_slave__124_ u_axi_slave__230_/VPB VSUBS VSUBS u_axi_slave__230_/VPB u_axi_slave__124_/A
+ u_axi_slave__124_/Y u_axi_slave__124_/B sky130_fd_sc_hd__nand2_1
Xu_async_fifo_fifomem__490_ u_async_fifo_fifomem__490_/Q u_async_fifo_fifomem__490_/CLK
+ u_async_fifo_fifomem__490_/D clkbuf_4_3_0_s_axi_aclk/VPB VSUBS clkbuf_4_3_0_s_axi_aclk/VPB
+ VSUBS sky130_fd_sc_hd__dfxtp_1
Xu_uart_tx__110_ VSUBS u_uart_tx__152_/VPB u_uart_tx__152_/VPB VSUBS u_uart_tx__110_/X
+ u_uart_tx__110_/B u_uart_tx__110_/A sky130_fd_sc_hd__and2_0
Xu_axi_slave__107_ u_axi_slave__107_/VPB VSUBS u_axi_slave__107_/VPB VSUBS u_axi_slave__107_/A2
+ u_axi_slave__107_/A1 u_axi_slave__107_/B1 u_axi_slave__107_/Y sky130_fd_sc_hd__a21oi_1
Xu_async_fifo_wptr_full__30_ VSUBS TAP_TAPCELL_ROW_21_293/VPWR u_async_fifo_wptr_full__30_/B
+ u_async_fifo_wptr_full__30_/Y u_async_fifo_wptr_full__30_/A TAP_TAPCELL_ROW_21_293/VPWR
+ VSUBS sky130_fd_sc_hd__xnor2_1
Xu_async_fifo_fifomem__473_ u_async_fifo_fifomem__473_/Q u_async_fifo_fifomem__473_/CLK
+ u_async_fifo_fifomem__473_/D TAP_TAPCELL_ROW_38_408/VPWR VSUBS TAP_TAPCELL_ROW_38_408/VPWR
+ VSUBS sky130_fd_sc_hd__dfxtp_1
X_26_ VSUBS _38_/VPB _38_/VPB VSUBS _26_/X _26_/A1 _26_/S _26_/A0 sky130_fd_sc_hd__mux2_1
Xu_async_fifo_fifomem__387_ u_async_fifo_fifomem__387_/Q u_async_fifo_fifomem__387_/CLK
+ u_async_fifo_fifomem__387_/D TAP_TAPCELL_ROW_39_416/VPWR VSUBS TAP_TAPCELL_ROW_39_416/VPWR
+ VSUBS sky130_fd_sc_hd__dfxtp_1
Xu_async_fifo_fifomem__456_ u_async_fifo_fifomem__456_/Q u_async_fifo_fifomem__456_/CLK
+ u_async_fifo_fifomem__456_/D TAP_TAPCELL_ROW_32_369/VPWR VSUBS TAP_TAPCELL_ROW_32_369/VPWR
+ VSUBS sky130_fd_sc_hd__dfxtp_1
Xu_async_fifo_fifomem__310_ u_async_fifo_fifomem__343_/VGND TAP_TAPCELL_ROW_24_311/VPWR
+ TAP_TAPCELL_ROW_24_311/VPWR VSUBS u_async_fifo_fifomem__310_/X u_async_fifo_fifomem__310_/A1
+ u_async_fifo_fifomem__310_/S u_async_fifo_fifomem__310_/A0 sky130_fd_sc_hd__mux2_1
Xu_async_fifo_fifomem__439_ u_async_fifo_fifomem__439_/Q u_async_fifo_fifomem__439_/CLK
+ u_async_fifo_fifomem__439_/D TAP_TAPCELL_ROW_21_290/VPWR VSUBS TAP_TAPCELL_ROW_21_290/VPWR
+ VSUBS sky130_fd_sc_hd__dfxtp_1
Xu_async_fifo_fifomem__241_ u_async_fifo_fifomem__389_/VGND u_async_fifo_fifomem__328_/VPWR
+ u_async_fifo_fifomem__328_/VPB VSUBS u_async_fifo_fifomem__241_/X u_async_fifo_fifomem__241_/A1
+ u_async_fifo_fifomem__241_/S u_async_fifo_fifomem__241_/A0 sky130_fd_sc_hd__mux2_1
XPHY_EDGE_ROW_1_Right_1 PHY_EDGE_ROW_1_Right_1/VPWR PHY_EDGE_ROW_2_Right_2/VGND PHY_EDGE_ROW_1_Right_1/VPB
+ VSUBS sky130_fd_sc_hd__decap_3
Xu_async_fifo_fifomem__224_ VSUBS TAP_TAPCELL_ROW_41_430/VPWR VSUBS TAP_TAPCELL_ROW_41_430/VPWR
+ u_async_fifo_fifomem__224_/S0 u_async_fifo_fifomem__224_/A2 u_async_fifo_fifomem__224_/A3
+ u_async_fifo_fifomem__224_/S1 u_async_fifo_fifomem__224_/A1 u_async_fifo_fifomem__224_/A0
+ u_async_fifo_fifomem__224_/X sky130_fd_sc_hd__mux4_2
XPHY_EDGE_ROW_39_Left_106 PHY_EDGE_ROW_39_Left_106/VPWR PHY_EDGE_ROW_40_Left_107/VGND
+ PHY_EDGE_ROW_39_Left_106/VPB VSUBS sky130_fd_sc_hd__decap_3
Xu_axi_slave__140_ ANTENNA_2/VPB VSUBS u_axi_slave__140_/VGND ANTENNA_2/VPB u_axi_slave__140_/A
+ u_axi_slave__140_/B u_axi_slave__140_/Y u_axi_slave__140_/C sky130_fd_sc_hd__nand3_1
XPHY_EDGE_ROW_57_Left_124 PHY_EDGE_ROW_57_Left_124/VPWR PHY_EDGE_ROW_58_Left_125/VGND
+ PHY_EDGE_ROW_57_Left_124/VPB VSUBS sky130_fd_sc_hd__decap_3
XPHY_EDGE_ROW_48_Left_115 PHY_EDGE_ROW_49_Left_116/VPWR PHY_EDGE_ROW_48_Left_115/VGND
+ PHY_EDGE_ROW_49_Left_116/VPB VSUBS sky130_fd_sc_hd__decap_3
XPHY_EDGE_ROW_66_Left_133 PHY_EDGE_ROW_66_Left_133/VPWR PHY_EDGE_ROW_66_Left_133/VGND
+ PHY_EDGE_ROW_66_Left_133/VPB VSUBS sky130_fd_sc_hd__decap_3
Xu_async_fifo_fifomem__207_ VSUBS TAP_TAPCELL_ROW_51_500/VPWR VSUBS TAP_TAPCELL_ROW_51_500/VPWR
+ u_async_fifo_fifomem__207_/S0 u_async_fifo_fifomem__207_/A2 u_async_fifo_fifomem__207_/A3
+ u_async_fifo_fifomem__207_/S1 u_async_fifo_fifomem__207_/A1 u_async_fifo_fifomem__207_/A0
+ u_async_fifo_fifomem__207_/X sky130_fd_sc_hd__mux4_2
Xu_axi_slave__123_ VSUBS u_axi_slave__199_/VPB u_axi_slave__199_/VPB VSUBS u_axi_slave__123_/A3
+ u_axi_slave__123_/A2 u_axi_slave__123_/A1 u_axi_slave__123_/Y u_axi_slave__123_/B1
+ sky130_fd_sc_hd__a31oi_1
Xload_slew1 VSUBS load_slew1/VPB VSUBS load_slew1/VPB load_slew1/A load_slew1/X sky130_fd_sc_hd__buf_16
Xu_axi_slave__106_ u_axi_slave__106_/VPB VSUBS VSUBS u_axi_slave__106_/VPB u_axi_slave__106_/A
+ u_axi_slave__106_/B u_axi_slave__106_/Y sky130_fd_sc_hd__nor2_1
Xu_async_fifo_fifomem__472_ u_async_fifo_fifomem__472_/Q u_async_fifo_fifomem__472_/CLK
+ u_async_fifo_fifomem__472_/D TAP_TAPCELL_ROW_34_380/VPWR VSUBS TAP_TAPCELL_ROW_34_380/VPWR
+ u_async_fifo_fifomem__472_/VGND sky130_fd_sc_hd__dfxtp_1
X_25_ VSUBS _37_/VPB _37_/VPB VSUBS _25_/X _25_/A1 _25_/S _25_/A0 sky130_fd_sc_hd__mux2_1
Xu_async_fifo_fifomem__386_ u_async_fifo_fifomem__386_/Q u_async_fifo_fifomem__386_/CLK
+ u_async_fifo_fifomem__386_/D u_async_fifo_fifomem__466_/VPB VSUBS u_async_fifo_fifomem__466_/VPWR
+ VSUBS sky130_fd_sc_hd__dfxtp_1
Xu_async_fifo_fifomem__455_ u_async_fifo_fifomem__455_/Q u_async_fifo_fifomem__455_/CLK
+ u_async_fifo_fifomem__455_/D TAP_TAPCELL_ROW_25_319/VPWR VSUBS TAP_TAPCELL_ROW_25_319/VPWR
+ VSUBS sky130_fd_sc_hd__dfxtp_1
XPHY_EDGE_ROW_27_Left_94 PHY_EDGE_ROW_27_Left_94/VPWR PHY_EDGE_ROW_28_Left_95/VGND
+ PHY_EDGE_ROW_27_Left_94/VPB VSUBS sky130_fd_sc_hd__decap_3
Xu_async_fifo_fifomem__240_ VSUBS TAP_TAPCELL_ROW_43_444/VPWR TAP_TAPCELL_ROW_43_444/VPWR
+ VSUBS u_async_fifo_fifomem__240_/X u_async_fifo_fifomem__240_/A1 u_async_fifo_fifomem__240_/S
+ u_async_fifo_fifomem__240_/A0 sky130_fd_sc_hd__mux2_1
XPHY_EDGE_ROW_11_Left_78 PHY_EDGE_ROW_11_Left_78/VPWR PHY_EDGE_ROW_12_Left_79/VGND
+ PHY_EDGE_ROW_11_Left_78/VPB VSUBS sky130_fd_sc_hd__decap_3
Xu_async_fifo_fifomem__438_ u_async_fifo_fifomem__438_/Q u_async_fifo_fifomem__438_/CLK
+ u_async_fifo_fifomem__438_/D u_async_fifo_fifomem__438_/VPB VSUBS u_async_fifo_fifomem__438_/VPWR
+ u_async_fifo_fifomem__478_/VGND sky130_fd_sc_hd__dfxtp_1
Xclkbuf_4_14_0_s_axi_aclk clkbuf_4_14_0_s_axi_aclk/X clkbuf_4_14_0_s_axi_aclk/A u_axi_slave__240_/VPB
+ VSUBS VSUBS u_axi_slave__240_/VPB sky130_fd_sc_hd__clkbuf_8
Xu_async_fifo_fifomem__369_ u_async_fifo_fifomem__369_/VPB VSUBS VSUBS u_async_fifo_fifomem__369_/VPWR
+ u_async_fifo_fifomem__369_/A_N u_async_fifo_fifomem__369_/B u_async_fifo_fifomem__369_/Y
+ sky130_fd_sc_hd__nand2b_1
Xu_async_fifo_fifomem__223_ VSUBS TAP_TAPCELL_ROW_43_446/VPWR VSUBS TAP_TAPCELL_ROW_43_446/VPWR
+ u_async_fifo_fifomem__223_/S0 u_async_fifo_fifomem__223_/A2 u_async_fifo_fifomem__223_/A3
+ u_async_fifo_fifomem__223_/S1 u_async_fifo_fifomem__223_/A1 u_async_fifo_fifomem__223_/A0
+ u_async_fifo_fifomem__223_/X sky130_fd_sc_hd__mux4_2
XPHY_EDGE_ROW_24_Right_24 PHY_EDGE_ROW_25_Right_25/VPWR PHY_EDGE_ROW_24_Right_24/VGND
+ PHY_EDGE_ROW_25_Right_25/VPB VSUBS sky130_fd_sc_hd__decap_3
XPHY_EDGE_ROW_15_Right_15 PHY_EDGE_ROW_15_Right_15/VPWR VSUBS PHY_EDGE_ROW_15_Right_15/VPB
+ VSUBS sky130_fd_sc_hd__decap_3
XPHY_EDGE_ROW_51_Right_51 PHY_EDGE_ROW_51_Right_51/VPWR PHY_EDGE_ROW_52_Right_52/VGND
+ PHY_EDGE_ROW_51_Right_51/VPB VSUBS sky130_fd_sc_hd__decap_3
XPHY_EDGE_ROW_42_Right_42 PHY_EDGE_ROW_43_Right_43/VPWR PHY_EDGE_ROW_42_Right_42/VGND
+ PHY_EDGE_ROW_43_Right_43/VPB VSUBS sky130_fd_sc_hd__decap_3
XPHY_EDGE_ROW_33_Right_33 PHY_EDGE_ROW_33_Right_33/VPWR VSUBS PHY_EDGE_ROW_33_Right_33/VPB
+ VSUBS sky130_fd_sc_hd__decap_3
XPHY_EDGE_ROW_60_Right_60 PHY_EDGE_ROW_61_Right_61/VPWR PHY_EDGE_ROW_60_Right_60/VGND
+ PHY_EDGE_ROW_61_Right_61/VPB VSUBS sky130_fd_sc_hd__decap_3
Xu_axi_slave__199_ VSUBS u_axi_slave__199_/VPB u_axi_slave__199_/VPB VSUBS u_axi_slave__199_/CLK
+ u_axi_slave__199_/D u_axi_slave__199_/RESET_B u_axi_slave__199_/Q sky130_fd_sc_hd__dfrtp_1
Xu_async_fifo_fifomem__206_ VSUBS TAP_TAPCELL_ROW_44_451/VPWR VSUBS TAP_TAPCELL_ROW_44_451/VPWR
+ u_async_fifo_fifomem__206_/S0 u_async_fifo_fifomem__206_/A2 u_async_fifo_fifomem__206_/A3
+ u_async_fifo_fifomem__206_/S1 u_async_fifo_fifomem__206_/A1 u_async_fifo_fifomem__206_/A0
+ u_async_fifo_fifomem__206_/X sky130_fd_sc_hd__mux4_2
Xu_axi_slave__122_ u_axi_slave__199_/VPB VSUBS VSUBS u_axi_slave__199_/VPB u_axi_slave__122_/A
+ u_axi_slave__122_/B u_axi_slave__122_/Y sky130_fd_sc_hd__nor2_1
XPHY_EDGE_ROW_14_Left_81 PHY_EDGE_ROW_15_Left_82/VPWR PHY_EDGE_ROW_14_Left_81/VGND
+ PHY_EDGE_ROW_15_Left_82/VPB VSUBS sky130_fd_sc_hd__decap_3
Xu_uart_tx__168_ VSUBS u_uart_tx__168_/VPB u_uart_tx__168_/VPB VSUBS u_uart_tx__168_/CLK
+ u_uart_tx__168_/D u_uart_tx__168_/RESET_B u_uart_tx__168_/Q sky130_fd_sc_hd__dfrtp_1
Xu_uart_tx__099_ u_uart_tx__163_/VPB VSUBS u_uart_tx__163_/VPB VSUBS u_uart_tx__099_/B
+ u_uart_tx__099_/C u_uart_tx__099_/A u_uart_tx__099_/X sky130_fd_sc_hd__or3_1
Xu_axi_slave__105_ u_axi_slave__159_/VPB VSUBS u_axi_slave__159_/VPB VSUBS u_axi_slave__105_/A2
+ u_axi_slave__105_/A1 u_axi_slave__105_/B1 u_axi_slave__105_/Y sky130_fd_sc_hd__a21oi_1
Xu_async_fifo_fifomem__471_ u_async_fifo_fifomem__471_/Q u_async_fifo_fifomem__471_/CLK
+ u_async_fifo_fifomem__471_/D TAP_TAPCELL_ROW_16_254/VPWR VSUBS TAP_TAPCELL_ROW_16_254/VPWR
+ VSUBS sky130_fd_sc_hd__dfxtp_1
X_24_ VSUBS _39_/VPB _39_/VPB VSUBS _24_/X _24_/A1 _24_/S _24_/A0 sky130_fd_sc_hd__mux2_1
Xu_async_fifo_fifomem__454_ u_async_fifo_fifomem__454_/Q u_async_fifo_fifomem__454_/CLK
+ u_async_fifo_fifomem__454_/D TAP_TAPCELL_ROW_49_487/VPWR VSUBS TAP_TAPCELL_ROW_49_487/VPWR
+ VSUBS sky130_fd_sc_hd__dfxtp_1
Xu_async_fifo_fifomem__385_ u_async_fifo_fifomem__385_/Q u_async_fifo_fifomem__385_/CLK
+ u_async_fifo_fifomem__385_/D clkbuf_4_5_0_s_axi_aclk/VPB VSUBS clkbuf_4_5_0_s_axi_aclk/VPB
+ VSUBS sky130_fd_sc_hd__dfxtp_1
Xu_async_fifo_fifomem__368_ VSUBS clkbuf_4_7_0_s_axi_aclk/VPB clkbuf_4_7_0_s_axi_aclk/VPB
+ VSUBS u_async_fifo_fifomem__368_/X u_async_fifo_fifomem__368_/A1 u_async_fifo_fifomem__368_/S
+ u_async_fifo_fifomem__368_/A0 sky130_fd_sc_hd__mux2_1
Xu_async_fifo_fifomem__299_ VSUBS u_async_fifo_fifomem__299_/VPWR u_async_fifo_fifomem__299_/VPB
+ VSUBS u_async_fifo_fifomem__299_/X u_async_fifo_fifomem__299_/A1 u_async_fifo_fifomem__299_/S
+ u_async_fifo_fifomem__299_/A0 sky130_fd_sc_hd__mux2_1
Xu_async_fifo_fifomem__437_ u_async_fifo_fifomem__437_/Q u_async_fifo_fifomem__437_/CLK
+ u_async_fifo_fifomem__437_/D TAP_TAPCELL_ROW_19_277/VPWR VSUBS TAP_TAPCELL_ROW_19_277/VPWR
+ VSUBS sky130_fd_sc_hd__dfxtp_1
Xu_async_fifo_fifomem__222_ VSUBS TAP_TAPCELL_ROW_41_431/VPWR VSUBS TAP_TAPCELL_ROW_41_431/VPWR
+ u_async_fifo_fifomem__222_/S0 u_async_fifo_fifomem__222_/A2 u_async_fifo_fifomem__222_/A3
+ u_async_fifo_fifomem__222_/S1 u_async_fifo_fifomem__222_/A1 u_async_fifo_fifomem__222_/A0
+ u_async_fifo_fifomem__222_/X sky130_fd_sc_hd__mux4_2
Xu_axi_slave__198_ VSUBS u_axi_slave__204_/VPB u_axi_slave__204_/VPB VSUBS u_axi_slave__198_/CLK
+ u_axi_slave__198_/D u_axi_slave__198_/RESET_B u_axi_slave__198_/Q sky130_fd_sc_hd__dfrtp_1
Xu_async_fifo_fifomem__205_ VSUBS TAP_TAPCELL_ROW_49_485/VPWR VSUBS TAP_TAPCELL_ROW_49_485/VPWR
+ u_async_fifo_fifomem__205_/S0 u_async_fifo_fifomem__205_/A2 u_async_fifo_fifomem__205_/A3
+ u_async_fifo_fifomem__205_/S1 u_async_fifo_fifomem__205_/A1 u_async_fifo_fifomem__205_/A0
+ u_async_fifo_fifomem__205_/X sky130_fd_sc_hd__mux4_2
Xu_axi_slave__121_ u_axi_slave__121_/VPB VSUBS u_axi_slave__121_/VPB VSUBS u_axi_slave__121_/B2
+ u_axi_slave__121_/B1 u_axi_slave__121_/Y u_axi_slave__121_/A1 u_axi_slave__121_/A2
+ sky130_fd_sc_hd__a22oi_1
Xclkbuf_3_7__f_uart_clk VSUBS clkbuf_0_uart_clk/VPB VSUBS clkbuf_0_uart_clk/VPB clkbuf_3_7__f_uart_clk/A
+ clkbuf_3_7__f_uart_clk/X sky130_fd_sc_hd__clkbuf_16
Xu_uart_tx__167_ VSUBS u_uart_tx__167_/VPB u_uart_tx__167_/VPB VSUBS u_uart_tx__167_/CLK
+ u_uart_tx__167_/D u_uart_tx__167_/RESET_B u_uart_tx__167_/Q sky130_fd_sc_hd__dfrtp_1
Xu_uart_tx__098_ u_uart_tx__153_/VPB u_uart_tx__122_/VGND u_uart_tx__153_/VPB VSUBS
+ u_uart_tx__098_/A2 u_uart_tx__098_/A1 u_uart_tx__098_/B1 u_uart_tx__098_/Y sky130_fd_sc_hd__a21oi_1
Xu_axi_slave__104_ VSUBS u_axi_slave__237_/VPB u_axi_slave__237_/VPB VSUBS u_axi_slave__104_/B
+ u_axi_slave__104_/C_N u_axi_slave__104_/A u_axi_slave__104_/X sky130_fd_sc_hd__or3b_1
Xu_async_fifo_fifomem__470_ u_async_fifo_fifomem__470_/Q u_async_fifo_fifomem__470_/CLK
+ u_async_fifo_fifomem__470_/D u_async_fifo_fifomem__470_/VPB VSUBS u_async_fifo_fifomem__470_/VPWR
+ VSUBS sky130_fd_sc_hd__dfxtp_1
X_23_ VSUBS _38_/VPB _38_/VPB VSUBS _23_/X _23_/A1 _23_/S _23_/A0 sky130_fd_sc_hd__mux2_1
Xu_async_fifo_fifomem__384_ u_async_fifo_fifomem__384_/Q u_async_fifo_fifomem__384_/CLK
+ u_async_fifo_fifomem__384_/D TAP_TAPCELL_ROW_35_387/VPWR VSUBS TAP_TAPCELL_ROW_35_387/VPWR
+ VSUBS sky130_fd_sc_hd__dfxtp_1
Xu_async_fifo_fifomem__453_ u_async_fifo_fifomem__453_/Q u_async_fifo_fifomem__453_/CLK
+ u_async_fifo_fifomem__453_/D load_slew1/VPB VSUBS load_slew1/VPB VSUBS sky130_fd_sc_hd__dfxtp_1
Xu_async_fifo_fifomem__436_ u_async_fifo_fifomem__436_/Q u_async_fifo_fifomem__436_/CLK
+ u_async_fifo_fifomem__436_/D TAP_TAPCELL_ROW_52_508/VPWR VSUBS TAP_TAPCELL_ROW_52_508/VPWR
+ VSUBS sky130_fd_sc_hd__dfxtp_1
Xu_async_fifo_fifomem__505_ u_async_fifo_fifomem__505_/Q u_async_fifo_fifomem__505_/CLK
+ u_async_fifo_fifomem__505_/D TAP_TAPCELL_ROW_43_446/VPWR VSUBS TAP_TAPCELL_ROW_43_446/VPWR
+ u_async_fifo_fifomem__505_/VGND sky130_fd_sc_hd__dfxtp_1
Xu_async_fifo_fifomem__367_ VSUBS TAP_TAPCELL_ROW_33_374/VPWR TAP_TAPCELL_ROW_33_374/VPWR
+ VSUBS u_async_fifo_fifomem__367_/X u_async_fifo_fifomem__367_/A1 u_async_fifo_fifomem__367_/S
+ u_async_fifo_fifomem__367_/A0 sky130_fd_sc_hd__mux2_1
Xu_async_fifo_fifomem__298_ VSUBS TAP_TAPCELL_ROW_29_346/VPWR TAP_TAPCELL_ROW_29_346/VPWR
+ VSUBS u_async_fifo_fifomem__298_/X u_async_fifo_fifomem__298_/A1 u_async_fifo_fifomem__298_/S
+ u_async_fifo_fifomem__298_/A0 sky130_fd_sc_hd__mux2_1
Xclkbuf_3_6__f_uart_clk VSUBS clkbuf_3_6__f_uart_clk/VPB VSUBS clkbuf_3_6__f_uart_clk/VPB
+ clkbuf_3_6__f_uart_clk/A clkbuf_3_6__f_uart_clk/X sky130_fd_sc_hd__clkbuf_16
Xu_async_fifo_fifomem__221_ VSUBS TAP_TAPCELL_ROW_39_415/VPWR VSUBS TAP_TAPCELL_ROW_39_415/VPWR
+ u_async_fifo_fifomem__221_/S0 u_async_fifo_fifomem__221_/A2 u_async_fifo_fifomem__221_/A3
+ u_async_fifo_fifomem__221_/S1 u_async_fifo_fifomem__221_/A1 u_async_fifo_fifomem__221_/A0
+ u_async_fifo_fifomem__221_/X sky130_fd_sc_hd__mux4_2
XPHY_EDGE_ROW_5_Right_5 PHY_EDGE_ROW_5_Right_5/VPWR PHY_EDGE_ROW_6_Right_6/VGND PHY_EDGE_ROW_5_Right_5/VPB
+ VSUBS sky130_fd_sc_hd__decap_3
Xu_axi_slave__197_ VSUBS u_axi_slave__197_/VPB u_axi_slave__197_/VPB VSUBS u_axi_slave__197_/CLK
+ u_axi_slave__197_/D u_axi_slave__197_/RESET_B u_axi_slave__197_/Q sky130_fd_sc_hd__dfrtp_1
Xu_async_fifo_fifomem__419_ u_async_fifo_fifomem__419_/Q u_async_fifo_fifomem__419_/CLK
+ u_async_fifo_fifomem__419_/D u_async_fifo_fifomem__459_/VPB VSUBS u_async_fifo_fifomem__459_/VPWR
+ u_async_fifo_fifomem__419_/VGND sky130_fd_sc_hd__dfxtp_1
XPHY_EDGE_ROW_35_Left_102 PHY_EDGE_ROW_35_Left_102/VPWR PHY_EDGE_ROW_36_Left_103/VGND
+ PHY_EDGE_ROW_35_Left_102/VPB VSUBS sky130_fd_sc_hd__decap_3
XPHY_EDGE_ROW_53_Left_120 PHY_EDGE_ROW_53_Left_120/VPWR PHY_EDGE_ROW_54_Left_121/VGND
+ PHY_EDGE_ROW_53_Left_120/VPB VSUBS sky130_fd_sc_hd__decap_3
XPHY_EDGE_ROW_44_Left_111 PHY_EDGE_ROW_45_Left_112/VPWR PHY_EDGE_ROW_44_Left_111/VGND
+ PHY_EDGE_ROW_45_Left_112/VPB VSUBS sky130_fd_sc_hd__decap_3
Xclkbuf_4_0_0_s_axi_aclk clkbuf_4_0_0_s_axi_aclk/X clkbuf_4_0_0_s_axi_aclk/A clkbuf_4_0_0_s_axi_aclk/VPB
+ VSUBS VSUBS clkbuf_4_0_0_s_axi_aclk/VPB sky130_fd_sc_hd__clkbuf_8
Xu_axi_slave__120_ u_axi_slave__233_/VPB VSUBS u_axi_slave__233_/VPB VSUBS u_axi_slave__120_/A2
+ u_axi_slave__120_/A1 u_axi_slave__120_/B1 u_axi_slave__120_/Y sky130_fd_sc_hd__a21oi_1
Xu_async_fifo_fifomem__204_ VSUBS TAP_TAPCELL_ROW_17_262/VPWR VSUBS TAP_TAPCELL_ROW_17_262/VPWR
+ u_async_fifo_fifomem__204_/S0 u_async_fifo_fifomem__204_/A2 u_async_fifo_fifomem__204_/A3
+ u_async_fifo_fifomem__204_/S1 u_async_fifo_fifomem__204_/A1 u_async_fifo_fifomem__204_/A0
+ u_async_fifo_fifomem__204_/X sky130_fd_sc_hd__mux4_2
Xu_uart_tx__166_ VSUBS u_uart_tx__166_/VPB u_uart_tx__166_/VPB VSUBS u_uart_tx__166_/CLK
+ u_uart_tx__166_/D u_uart_tx__166_/RESET_B u_uart_tx__166_/Q sky130_fd_sc_hd__dfrtp_1
Xu_uart_tx__097_ u_uart_tx__152_/VPB VSUBS u_uart_tx__152_/VPB VSUBS u_uart_tx__097_/A2
+ u_uart_tx__097_/A1 u_uart_tx__097_/B1 u_uart_tx__097_/X sky130_fd_sc_hd__a21o_1
Xu_axi_slave__103_ u_axi_slave__237_/VPB VSUBS VSUBS u_axi_slave__237_/VPB u_axi_slave__103_/C_N
+ u_axi_slave__103_/B u_axi_slave__103_/Y u_axi_slave__103_/A sky130_fd_sc_hd__nor3b_1
Xu_uart_tx__149_ VSUBS u_uart_tx__152_/VPB u_uart_tx__152_/VPB VSUBS u_uart_tx__149_/CLK
+ u_uart_tx__149_/D u_uart_tx__149_/RESET_B u_uart_tx__149_/Q sky130_fd_sc_hd__dfrtp_1
X_22_ VSUBS _22_/VPB _22_/VPB VSUBS _22_/X _22_/A1 _22_/S _22_/A0 sky130_fd_sc_hd__mux2_1
Xu_async_fifo_fifomem__452_ u_async_fifo_fifomem__452_/Q u_async_fifo_fifomem__452_/CLK
+ u_async_fifo_fifomem__452_/D TAP_TAPCELL_ROW_48_481/VPWR VSUBS TAP_TAPCELL_ROW_48_481/VPWR
+ VSUBS sky130_fd_sc_hd__dfxtp_1
Xu_async_fifo_fifomem__383_ u_async_fifo_fifomem__383_/Q u_async_fifo_fifomem__383_/CLK
+ u_async_fifo_fifomem__383_/D TAP_TAPCELL_ROW_21_289/VPWR VSUBS TAP_TAPCELL_ROW_21_289/VPWR
+ VSUBS sky130_fd_sc_hd__dfxtp_1
Xclkbuf_4_5_0_s_axi_aclk clkbuf_4_5_0_s_axi_aclk/X clkbuf_4_5_0_s_axi_aclk/A clkbuf_4_5_0_s_axi_aclk/VPB
+ VSUBS VSUBS clkbuf_4_5_0_s_axi_aclk/VPB sky130_fd_sc_hd__clkbuf_8
Xclkbuf_3_5__f_uart_clk VSUBS u_uart_tx__152_/VPB VSUBS u_uart_tx__152_/VPB clkbuf_3_5__f_uart_clk/A
+ clkbuf_3_5__f_uart_clk/X sky130_fd_sc_hd__clkbuf_16
Xu_async_fifo_fifomem__435_ u_async_fifo_fifomem__435_/Q u_async_fifo_fifomem__435_/CLK
+ u_async_fifo_fifomem__435_/D TAP_TAPCELL_ROW_35_388/VPWR VSUBS TAP_TAPCELL_ROW_35_388/VPWR
+ VSUBS sky130_fd_sc_hd__dfxtp_1
Xu_async_fifo_fifomem__504_ u_async_fifo_fifomem__504_/Q u_async_fifo_fifomem__504_/CLK
+ u_async_fifo_fifomem__504_/D TAP_TAPCELL_ROW_32_369/VPWR VSUBS TAP_TAPCELL_ROW_32_369/VPWR
+ VSUBS sky130_fd_sc_hd__dfxtp_1
Xu_async_fifo_fifomem__297_ TAP_TAPCELL_ROW_24_312/VPWR VSUBS VSUBS TAP_TAPCELL_ROW_24_312/VPWR
+ u_async_fifo_fifomem__297_/A u_async_fifo_fifomem__297_/B u_async_fifo_fifomem__297_/Y
+ sky130_fd_sc_hd__nor2_1
Xu_async_fifo_fifomem__366_ VSUBS TAP_TAPCELL_ROW_19_276/VPWR TAP_TAPCELL_ROW_19_276/VPWR
+ VSUBS u_async_fifo_fifomem__366_/X u_async_fifo_fifomem__366_/A1 u_async_fifo_fifomem__366_/S
+ u_async_fifo_fifomem__366_/A0 sky130_fd_sc_hd__mux2_1
Xu_async_fifo_fifomem__220_ VSUBS clkbuf_4_5_0_s_axi_aclk/VPB u_async_fifo_fifomem__449_/VGND
+ clkbuf_4_5_0_s_axi_aclk/VPB u_async_fifo_fifomem__220_/S0 u_async_fifo_fifomem__220_/A2
+ u_async_fifo_fifomem__220_/A3 u_async_fifo_fifomem__220_/S1 u_async_fifo_fifomem__220_/A1
+ u_async_fifo_fifomem__220_/A0 u_async_fifo_fifomem__220_/X sky130_fd_sc_hd__mux4_2
Xu_axi_slave__196_ VSUBS u_axi_slave__197_/VPB u_axi_slave__197_/VPB VSUBS u_axi_slave__196_/CLK
+ u_axi_slave__196_/D u_axi_slave__196_/RESET_B u_axi_slave__196_/Q sky130_fd_sc_hd__dfrtp_1
Xu_async_fifo_fifomem__349_ VSUBS TAP_TAPCELL_ROW_31_359/VPWR TAP_TAPCELL_ROW_31_359/VPWR
+ VSUBS u_async_fifo_fifomem__349_/X u_async_fifo_fifomem__349_/A1 u_async_fifo_fifomem__349_/S
+ u_async_fifo_fifomem__349_/A0 sky130_fd_sc_hd__mux2_1
Xu_async_fifo_fifomem__418_ u_async_fifo_fifomem__418_/Q u_async_fifo_fifomem__418_/CLK
+ u_async_fifo_fifomem__418_/D TAP_TAPCELL_ROW_27_331/VPWR VSUBS TAP_TAPCELL_ROW_27_331/VPWR
+ VSUBS sky130_fd_sc_hd__dfxtp_1
XPHY_EDGE_ROW_20_Right_20 PHY_EDGE_ROW_21_Right_21/VPWR PHY_EDGE_ROW_20_Right_20/VGND
+ PHY_EDGE_ROW_21_Right_21/VPB VSUBS sky130_fd_sc_hd__decap_3
XPHY_EDGE_ROW_11_Right_11 PHY_EDGE_ROW_11_Right_11/VPWR VSUBS PHY_EDGE_ROW_11_Right_11/VPB
+ VSUBS sky130_fd_sc_hd__decap_3
Xu_async_fifo_fifomem__203_ VSUBS TAP_TAPCELL_ROW_19_277/VPWR VSUBS TAP_TAPCELL_ROW_19_277/VPWR
+ u_async_fifo_fifomem__203_/S0 u_async_fifo_fifomem__203_/A2 u_async_fifo_fifomem__203_/A3
+ u_async_fifo_fifomem__203_/S1 u_async_fifo_fifomem__203_/A1 u_async_fifo_fifomem__203_/A0
+ u_async_fifo_fifomem__203_/X sky130_fd_sc_hd__mux4_2
Xu_axi_slave__179_ VSUBS u_axi_slave__228_/VPB u_axi_slave__228_/VPB VSUBS u_axi_slave__179_/X
+ u_axi_slave__179_/A1 u_axi_slave__179_/S u_axi_slave__179_/A0 sky130_fd_sc_hd__mux2_1
Xu_axi_slave__102_ u_axi_slave__102_/VPB VSUBS VSUBS u_axi_slave__102_/VPWR u_axi_slave__102_/A
+ u_axi_slave__102_/Y sky130_fd_sc_hd__clkinv_1
Xu_uart_tx__165_ VSUBS u_uart_tx__165_/VPB u_uart_tx__165_/VPB VSUBS u_uart_tx__165_/CLK
+ u_uart_tx__165_/D u_uart_tx__165_/RESET_B u_uart_tx__165_/Q sky130_fd_sc_hd__dfrtp_1
Xu_uart_tx__096_ VSUBS u_uart_tx__167_/VPB u_uart_tx__167_/VPB VSUBS u_uart_tx__096_/A3
+ u_uart_tx__096_/A2 u_uart_tx__096_/A1 u_uart_tx__096_/Y u_uart_tx__096_/B1 sky130_fd_sc_hd__a31oi_1
XPHY_EDGE_ROW_18_Left_85 PHY_EDGE_ROW_19_Left_86/VPWR PHY_EDGE_ROW_18_Left_85/VGND
+ PHY_EDGE_ROW_19_Left_86/VPB VSUBS sky130_fd_sc_hd__decap_3
Xu_uart_tx__148_ VSUBS u_uart_tx__148_/VPWR u_uart_tx__148_/VPB VSUBS u_uart_tx__148_/CLK
+ u_uart_tx__148_/D u_uart_tx__148_/RESET_B u_uart_tx__148_/Q sky130_fd_sc_hd__dfrtp_1
Xu_uart_tx__079_ VSUBS u_uart_tx__143_/VPB u_uart_tx__143_/VPB VSUBS u_uart_tx__079_/X
+ u_uart_tx__079_/A1 u_uart_tx__079_/S u_uart_tx__079_/A0 sky130_fd_sc_hd__mux2_1
Xclkbuf_3_4__f_uart_clk VSUBS u_uart_tx__168_/VPB VSUBS u_uart_tx__168_/VPB clkbuf_3_4__f_uart_clk/A
+ clkbuf_3_4__f_uart_clk/X sky130_fd_sc_hd__clkbuf_16
X_21_ VSUBS _30_/VPB _30_/VPB VSUBS _21_/X _21_/A1 _21_/S _21_/A0 sky130_fd_sc_hd__mux2_1
XPHY_EDGE_ROW_58_Right_58 PHY_EDGE_ROW_59_Right_59/VPWR PHY_EDGE_ROW_58_Right_58/VGND
+ PHY_EDGE_ROW_59_Right_59/VPB VSUBS sky130_fd_sc_hd__decap_3
XPHY_EDGE_ROW_49_Right_49 PHY_EDGE_ROW_49_Right_49/VPWR PHY_EDGE_ROW_50_Right_50/VGND
+ PHY_EDGE_ROW_49_Right_49/VPB VSUBS sky130_fd_sc_hd__decap_3
Xu_async_fifo_fifomem__382_ u_async_fifo_fifomem__382_/Q u_async_fifo_fifomem__382_/CLK
+ u_async_fifo_fifomem__382_/D TAP_TAPCELL_ROW_47_471/VPWR VSUBS TAP_TAPCELL_ROW_47_471/VPWR
+ VSUBS sky130_fd_sc_hd__dfxtp_1
Xu_async_fifo_fifomem__451_ u_async_fifo_fifomem__451_/Q u_async_fifo_fifomem__451_/CLK
+ u_async_fifo_fifomem__451_/D TAP_TAPCELL_ROW_38_411/VPWR VSUBS TAP_TAPCELL_ROW_38_411/VPWR
+ VSUBS sky130_fd_sc_hd__dfxtp_1
Xu_async_fifo_fifomem__365_ VSUBS TAP_TAPCELL_ROW_49_486/VPWR TAP_TAPCELL_ROW_49_486/VPWR
+ VSUBS u_async_fifo_fifomem__365_/X u_async_fifo_fifomem__365_/A1 u_async_fifo_fifomem__365_/S
+ u_async_fifo_fifomem__365_/A0 sky130_fd_sc_hd__mux2_1
Xu_async_fifo_fifomem__434_ u_async_fifo_fifomem__434_/Q u_async_fifo_fifomem__434_/CLK
+ u_async_fifo_fifomem__434_/D TAP_TAPCELL_ROW_29_346/VPWR VSUBS TAP_TAPCELL_ROW_29_346/VPWR
+ VSUBS sky130_fd_sc_hd__dfxtp_1
Xu_async_fifo_fifomem__503_ u_async_fifo_fifomem__503_/Q u_async_fifo_fifomem__503_/CLK
+ u_async_fifo_fifomem__503_/D TAP_TAPCELL_ROW_21_291/VPWR VSUBS TAP_TAPCELL_ROW_21_291/VPWR
+ VSUBS sky130_fd_sc_hd__dfxtp_1
Xu_async_fifo_fifomem__296_ TAP_TAPCELL_ROW_24_312/VPWR VSUBS VSUBS TAP_TAPCELL_ROW_24_312/VPWR
+ u_async_fifo_fifomem__296_/A u_async_fifo_fifomem__296_/B u_async_fifo_fifomem__296_/Y
+ u_async_fifo_fifomem__296_/C sky130_fd_sc_hd__nand3_1
XPHY_EDGE_ROW_6_Left_73 PHY_EDGE_ROW_7_Left_74/VPWR PHY_EDGE_ROW_6_Left_73/VGND PHY_EDGE_ROW_7_Left_74/VPB
+ VSUBS sky130_fd_sc_hd__decap_3
Xu_async_fifo_fifomem__417_ u_async_fifo_fifomem__417_/Q u_async_fifo_fifomem__417_/CLK
+ u_async_fifo_fifomem__417_/D TAP_TAPCELL_ROW_39_415/VPWR VSUBS TAP_TAPCELL_ROW_39_415/VPWR
+ VSUBS sky130_fd_sc_hd__dfxtp_1
Xu_async_fifo_fifomem__279_ u_async_fifo_fifomem__419_/VGND u_async_fifo_fifomem__279_/VPWR
+ u_async_fifo_fifomem__279_/VPB VSUBS u_async_fifo_fifomem__279_/X u_async_fifo_fifomem__279_/A1
+ u_async_fifo_fifomem__279_/S u_async_fifo_fifomem__279_/A0 sky130_fd_sc_hd__mux2_1
Xu_axi_slave__195_ VSUBS u_axi_slave__195_/VPB u_axi_slave__195_/VPB VSUBS u_axi_slave__195_/X
+ u_axi_slave__195_/A1 u_axi_slave__195_/S u_axi_slave__195_/A0 sky130_fd_sc_hd__mux2_1
XPHY_EDGE_ROW_32_Left_99 PHY_EDGE_ROW_32_Left_99/VPWR PHY_EDGE_ROW_32_Left_99/VGND
+ PHY_EDGE_ROW_32_Left_99/VPB VSUBS sky130_fd_sc_hd__decap_3
Xu_async_fifo_fifomem__348_ VSUBS u_async_fifo_fifomem__348_/VPWR u_async_fifo_fifomem__348_/VPB
+ VSUBS u_async_fifo_fifomem__348_/X u_async_fifo_fifomem__348_/A1 u_async_fifo_fifomem__348_/S
+ u_async_fifo_fifomem__348_/A0 sky130_fd_sc_hd__mux2_1
Xu_async_fifo_fifomem__202_ VSUBS TAP_TAPCELL_ROW_22_297/VPWR VSUBS TAP_TAPCELL_ROW_22_297/VPWR
+ u_async_fifo_fifomem__202_/S0 u_async_fifo_fifomem__202_/A2 u_async_fifo_fifomem__202_/A3
+ u_async_fifo_fifomem__202_/S1 u_async_fifo_fifomem__202_/A1 u_async_fifo_fifomem__202_/A0
+ u_async_fifo_fifomem__202_/X sky130_fd_sc_hd__mux4_2
Xu_axi_slave__178_ VSUBS u_axi_slave__227_/VPB u_axi_slave__227_/VPB VSUBS u_axi_slave__178_/X
+ u_axi_slave__178_/A1 u_axi_slave__178_/S u_axi_slave__178_/A0 sky130_fd_sc_hd__mux2_1
Xu_async_fifo_rptr_empty__39_ VSUBS TAP_TAPCELL_ROW_18_271/VPWR TAP_TAPCELL_ROW_18_271/VPWR
+ VSUBS u_async_fifo_rptr_empty__39_/CLK u_async_fifo_rptr_empty__39_/D u_async_fifo_rptr_empty__39_/RESET_B
+ u_async_fifo_rptr_empty__39_/Q sky130_fd_sc_hd__dfrtp_1
Xu_uart_tx__164_ VSUBS u_uart_tx__165_/VPB u_uart_tx__165_/VPB VSUBS u_uart_tx__164_/CLK
+ u_uart_tx__164_/D u_uart_tx__164_/RESET_B u_uart_tx__164_/Q sky130_fd_sc_hd__dfrtp_1
Xu_uart_tx__095_ VSUBS u_uart_tx__132_/VPB VSUBS u_uart_tx__132_/VPWR u_uart_tx__095_/B1
+ u_uart_tx__095_/A1 u_uart_tx__095_/Y u_uart_tx__095_/A2 sky130_fd_sc_hd__o21ai_0
Xu_axi_slave__101_ u_axi_slave__237_/VPB VSUBS u_axi_slave__237_/VPB VSUBS u_axi_slave__101_/B
+ u_axi_slave__101_/D u_axi_slave__101_/C u_axi_slave__101_/A u_axi_slave__101_/X
+ sky130_fd_sc_hd__or4_1
Xclkbuf_3_3__f_uart_clk VSUBS clkbuf_3_3__f_uart_clk/VPB VSUBS clkbuf_3_3__f_uart_clk/VPB
+ clkbuf_3_3__f_uart_clk/A clkbuf_3_3__f_uart_clk/X sky130_fd_sc_hd__clkbuf_16
Xu_uart_tx__147_ VSUBS u_uart_tx__167_/VPB u_uart_tx__167_/VPB VSUBS u_uart_tx__147_/CLK
+ u_uart_tx__147_/D u_uart_tx__160_/RESET_B u_uart_tx__147_/Q sky130_fd_sc_hd__dfrtp_1
Xu_uart_tx__078_ VSUBS _39_/VPB _39_/VPB VSUBS u_uart_tx__078_/X u_uart_tx__078_/A1
+ u_uart_tx__078_/S u_uart_tx__078_/A0 sky130_fd_sc_hd__mux2_1
X_20_ VSUBS _35_/VPB _35_/VPB VSUBS _20_/X _20_/A1 _20_/S _20_/A0 sky130_fd_sc_hd__mux2_1
Xu_async_fifo_fifomem__450_ u_async_fifo_fifomem__450_/Q u_async_fifo_fifomem__450_/CLK
+ u_async_fifo_fifomem__450_/D clkbuf_0_s_axi_aclk/VPB VSUBS clkbuf_0_s_axi_aclk/VPB
+ VSUBS sky130_fd_sc_hd__dfxtp_1
Xu_async_fifo_fifomem__381_ u_async_fifo_fifomem__381_/Q u_async_fifo_fifomem__381_/CLK
+ u_async_fifo_fifomem__381_/D TAP_TAPCELL_ROW_22_297/VPWR VSUBS TAP_TAPCELL_ROW_22_297/VPWR
+ u_async_fifo_fifomem__381_/VGND sky130_fd_sc_hd__dfxtp_1
Xu_async_fifo_fifomem__502_ u_async_fifo_fifomem__502_/Q u_async_fifo_fifomem__502_/CLK
+ u_async_fifo_fifomem__502_/D TAP_TAPCELL_ROW_47_473/VPWR VSUBS TAP_TAPCELL_ROW_47_473/VPWR
+ VSUBS sky130_fd_sc_hd__dfxtp_1
Xu_async_fifo_fifomem__433_ u_async_fifo_fifomem__433_/Q u_async_fifo_fifomem__433_/CLK
+ u_async_fifo_fifomem__433_/D clkbuf_4_13_0_s_axi_aclk/VPB VSUBS clkbuf_4_13_0_s_axi_aclk/VPWR
+ VSUBS sky130_fd_sc_hd__dfxtp_1
Xu_async_fifo_fifomem__295_ clkbuf_4_13_0_s_axi_aclk/VGND clkbuf_4_13_0_s_axi_aclk/VPWR
+ clkbuf_4_13_0_s_axi_aclk/VPB VSUBS u_async_fifo_fifomem__295_/X u_async_fifo_fifomem__295_/A1
+ u_async_fifo_fifomem__295_/S u_async_fifo_fifomem__295_/A0 sky130_fd_sc_hd__mux2_1
Xu_async_fifo_fifomem__364_ u_async_fifo_fifomem__364_/VGND u_async_fifo_fifomem__493_/VPWR
+ u_async_fifo_fifomem__493_/VPB VSUBS u_async_fifo_fifomem__364_/X u_async_fifo_fifomem__364_/A1
+ u_async_fifo_fifomem__364_/S u_async_fifo_fifomem__364_/A0 sky130_fd_sc_hd__mux2_1
Xu_async_fifo_fifomem__347_ VSUBS TAP_TAPCELL_ROW_51_500/VPWR TAP_TAPCELL_ROW_51_500/VPWR
+ VSUBS u_async_fifo_fifomem__347_/X u_async_fifo_fifomem__347_/A1 u_async_fifo_fifomem__347_/S
+ u_async_fifo_fifomem__347_/A0 sky130_fd_sc_hd__mux2_1
Xu_async_fifo_fifomem__416_ u_async_fifo_fifomem__416_/Q u_async_fifo_fifomem__416_/CLK
+ u_async_fifo_fifomem__416_/D TAP_TAPCELL_ROW_34_380/VPWR VSUBS TAP_TAPCELL_ROW_34_380/VPWR
+ VSUBS sky130_fd_sc_hd__dfxtp_1
Xu_async_fifo_fifomem__278_ VSUBS clkbuf_4_0_0_s_axi_aclk/VPB clkbuf_4_0_0_s_axi_aclk/VPB
+ VSUBS u_async_fifo_fifomem__278_/X u_async_fifo_fifomem__278_/A1 u_async_fifo_fifomem__278_/S
+ u_async_fifo_fifomem__278_/A0 sky130_fd_sc_hd__mux2_1
Xu_axi_slave__194_ u_axi_slave__194_/VGND u_axi_slave__211_/VPB u_axi_slave__211_/VPB
+ VSUBS u_axi_slave__194_/X u_axi_slave__194_/A1 u_axi_slave__194_/S u_axi_slave__194_/A0
+ sky130_fd_sc_hd__mux2_1
XPHY_EDGE_ROW_9_Right_9 PHY_EDGE_ROW_9_Right_9/VPWR PHY_EDGE_ROW_9_Right_9/VGND PHY_EDGE_ROW_9_Right_9/VPB
+ VSUBS sky130_fd_sc_hd__decap_3
Xu_async_fifo_fifomem__201_ VSUBS u_axi_slave__232_/VPB VSUBS u_axi_slave__232_/VPB
+ u_async_fifo_fifomem__201_/S0 u_async_fifo_fifomem__201_/A2 u_async_fifo_fifomem__201_/A3
+ u_async_fifo_fifomem__201_/S1 u_async_fifo_fifomem__201_/A1 u_async_fifo_fifomem__201_/A0
+ u_async_fifo_fifomem__201_/X sky130_fd_sc_hd__mux4_2
Xclkbuf_3_2__f_uart_clk VSUBS _22_/VPB VSUBS _22_/VPB clkbuf_3_2__f_uart_clk/A clkbuf_3_2__f_uart_clk/X
+ sky130_fd_sc_hd__clkbuf_16
Xu_axi_slave__177_ VSUBS u_axi_slave__233_/VPB u_axi_slave__233_/VPB VSUBS u_axi_slave__177_/X
+ u_axi_slave__177_/A1 u_axi_slave__177_/S u_axi_slave__177_/A0 sky130_fd_sc_hd__mux2_1
Xu_uart_tx__094_ u_uart_tx__132_/VPWR VSUBS u_uart_tx__132_/VPB VSUBS u_uart_tx__094_/A2
+ u_uart_tx__094_/A1 u_uart_tx__094_/B1 u_uart_tx__094_/Y sky130_fd_sc_hd__a21oi_1
Xu_uart_tx__163_ VSUBS u_uart_tx__163_/VPB u_uart_tx__163_/VPB VSUBS u_uart_tx__163_/CLK
+ u_uart_tx__163_/D u_uart_tx__163_/RESET_B u_uart_tx__163_/Q sky130_fd_sc_hd__dfrtp_1
Xu_async_fifo_rptr_empty__38_ clkbuf_0_uart_clk/VPB VSUBS clkbuf_0_uart_clk/VPB VSUBS
+ u_async_fifo_rptr_empty__38_/Q u_async_fifo_rptr_empty__38_/SET_B u_async_fifo_rptr_empty__38_/D
+ u_async_fifo_rptr_empty__38_/CLK sky130_fd_sc_hd__dfstp_2
Xu_axi_slave__100_ u_axi_slave__154_/VPB VSUBS VSUBS u_axi_slave__154_/VPB u_axi_slave__100_/A
+ u_axi_slave__100_/Y u_axi_slave__100_/B sky130_fd_sc_hd__nand2_1
Xu_axi_slave__229_ VSUBS u_axi_slave__244_/VPB u_axi_slave__244_/VPB VSUBS u_axi_slave__229_/CLK
+ u_axi_slave__229_/D u_axi_slave__229_/RESET_B u_axi_slave__229_/Q sky130_fd_sc_hd__dfrtp_1
Xu_uart_tx__146_ u_uart_tx__150_/VPB VSUBS u_uart_tx__150_/VPB VSUBS u_uart_tx__146_/Q
+ u_uart_tx__146_/SET_B u_uart_tx__146_/D u_uart_tx__146_/CLK sky130_fd_sc_hd__dfstp_2
Xu_uart_tx__077_ VSUBS _39_/VPB _39_/VPB VSUBS u_uart_tx__077_/X u_uart_tx__077_/A1
+ u_uart_tx__077_/S u_uart_tx__077_/A0 sky130_fd_sc_hd__mux2_1
Xu_async_fifo_fifomem__380_ u_async_fifo_fifomem__380_/Q u_async_fifo_fifomem__380_/CLK
+ u_async_fifo_fifomem__380_/D TAP_TAPCELL_ROW_48_479/VPWR VSUBS TAP_TAPCELL_ROW_48_479/VPWR
+ VSUBS sky130_fd_sc_hd__dfxtp_1
Xclkbuf_0_s_axi_aclk VSUBS clkbuf_0_s_axi_aclk/VPB VSUBS clkbuf_0_s_axi_aclk/VPB clkbuf_0_s_axi_aclk/A
+ clkbuf_0_s_axi_aclk/X sky130_fd_sc_hd__clkbuf_16
Xu_uart_tx__129_ u_uart_tx__166_/VPB VSUBS u_uart_tx__166_/VPB VSUBS u_uart_tx__129_/A2
+ u_uart_tx__129_/A1 u_uart_tx__129_/B1 u_uart_tx__129_/Y sky130_fd_sc_hd__a21oi_1
Xu_async_fifo_fifomem__363_ u_async_fifo_fifomem__363_/VGND u_async_fifo_fifomem__492_/VPWR
+ u_async_fifo_fifomem__492_/VPB VSUBS u_async_fifo_fifomem__363_/X u_async_fifo_fifomem__363_/A1
+ u_async_fifo_fifomem__363_/S u_async_fifo_fifomem__363_/A0 sky130_fd_sc_hd__mux2_1
Xu_async_fifo_fifomem__432_ u_async_fifo_fifomem__432_/Q u_async_fifo_fifomem__432_/CLK
+ u_async_fifo_fifomem__432_/D TAP_TAPCELL_ROW_32_369/VPWR VSUBS TAP_TAPCELL_ROW_32_369/VPWR
+ VSUBS sky130_fd_sc_hd__dfxtp_1
Xu_async_fifo_fifomem__294_ VSUBS clkbuf_0_s_axi_aclk/VPB clkbuf_0_s_axi_aclk/VPB
+ VSUBS u_async_fifo_fifomem__294_/X u_async_fifo_fifomem__294_/A1 u_async_fifo_fifomem__294_/S
+ u_async_fifo_fifomem__294_/A0 sky130_fd_sc_hd__mux2_1
Xu_async_fifo_fifomem__501_ u_async_fifo_fifomem__501_/Q u_async_fifo_fifomem__501_/CLK
+ u_async_fifo_fifomem__501_/D u_axi_slave__232_/VPB VSUBS u_axi_slave__232_/VPB VSUBS
+ sky130_fd_sc_hd__dfxtp_1
Xclkbuf_3_1__f_uart_clk VSUBS u_uart_tx__167_/VPB VSUBS u_uart_tx__167_/VPB clkbuf_3_1__f_uart_clk/A
+ clkbuf_3_1__f_uart_clk/X sky130_fd_sc_hd__clkbuf_16
Xu_async_fifo_fifomem__415_ u_async_fifo_fifomem__415_/Q u_async_fifo_fifomem__415_/CLK
+ u_async_fifo_fifomem__415_/D TAP_TAPCELL_ROW_16_254/VPWR VSUBS TAP_TAPCELL_ROW_16_254/VPWR
+ VSUBS sky130_fd_sc_hd__dfxtp_1
Xu_async_fifo_fifomem__346_ VSUBS TAP_TAPCELL_ROW_17_262/VPWR TAP_TAPCELL_ROW_17_262/VPWR
+ VSUBS u_async_fifo_fifomem__346_/X u_async_fifo_fifomem__346_/A1 u_async_fifo_fifomem__346_/S
+ u_async_fifo_fifomem__346_/A0 sky130_fd_sc_hd__mux2_1
Xu_axi_slave__193_ VSUBS u_axi_slave__227_/VPB u_axi_slave__227_/VPB VSUBS u_axi_slave__193_/X
+ u_axi_slave__193_/A1 u_axi_slave__193_/S u_axi_slave__193_/A0 sky130_fd_sc_hd__mux2_1
Xu_async_fifo_fifomem__277_ clkbuf_4_2_0_s_axi_aclk/VPB VSUBS VSUBS clkbuf_4_2_0_s_axi_aclk/VPB
+ u_async_fifo_fifomem__277_/A u_async_fifo_fifomem__277_/B u_async_fifo_fifomem__277_/Y
+ sky130_fd_sc_hd__nor2_1
Xu_async_fifo_fifomem__200_ VSUBS TAP_TAPCELL_ROW_17_262/VPWR VSUBS TAP_TAPCELL_ROW_17_262/VPWR
+ u_async_fifo_fifomem__200_/S0 u_async_fifo_fifomem__200_/A2 u_async_fifo_fifomem__200_/A3
+ u_async_fifo_fifomem__200_/S1 u_async_fifo_fifomem__200_/A1 u_async_fifo_fifomem__200_/A0
+ u_async_fifo_fifomem__200_/X sky130_fd_sc_hd__mux4_2
Xu_async_fifo_fifomem__329_ VSUBS TAP_TAPCELL_ROW_49_485/VPWR TAP_TAPCELL_ROW_49_485/VPWR
+ VSUBS u_async_fifo_fifomem__329_/X u_async_fifo_fifomem__329_/A1 u_async_fifo_fifomem__329_/S
+ u_async_fifo_fifomem__329_/A0 sky130_fd_sc_hd__mux2_1
Xu_axi_slave__176_ VSUBS ANTENNA_2/VPB ANTENNA_2/VPB VSUBS u_axi_slave__176_/X u_axi_slave__176_/A1
+ u_axi_slave__176_/S u_axi_slave__176_/A0 sky130_fd_sc_hd__mux2_1
Xu_uart_tx__093_ VSUBS u_uart_tx__132_/VPB VSUBS u_uart_tx__132_/VPWR u_uart_tx__093_/B1
+ u_uart_tx__093_/A1 u_uart_tx__093_/Y u_uart_tx__093_/A2 sky130_fd_sc_hd__o21ai_0
Xu_uart_tx__162_ VSUBS u_uart_tx__162_/VPB u_uart_tx__162_/VPB VSUBS u_uart_tx__162_/CLK
+ u_uart_tx__162_/D u_uart_tx__162_/RESET_B u_uart_tx__162_/Q sky130_fd_sc_hd__dfrtp_1
Xu_async_fifo_rptr_empty__37_ TAP_TAPCELL_ROW_12_229/VPWR VSUBS VSUBS TAP_TAPCELL_ROW_12_229/VPWR
+ u_async_fifo_rptr_empty__37_/A u_async_fifo_rptr_empty__37_/B u_async_fifo_rptr_empty__37_/Y
+ sky130_fd_sc_hd__nor2_1
XPHY_EDGE_ROW_50_Left_117 PHY_EDGE_ROW_51_Left_118/VPWR PHY_EDGE_ROW_50_Left_117/VGND
+ PHY_EDGE_ROW_51_Left_118/VPB VSUBS sky130_fd_sc_hd__decap_3
Xu_axi_slave__159_ u_axi_slave__159_/VPB VSUBS u_axi_slave__159_/X u_axi_slave__159_/A3
+ u_axi_slave__159_/A2 u_axi_slave__159_/A1 u_axi_slave__159_/B1 VSUBS u_axi_slave__159_/VPB
+ sky130_fd_sc_hd__a31o_1
XPHY_EDGE_ROW_41_Left_108 PHY_EDGE_ROW_41_Left_108/VPWR PHY_EDGE_ROW_42_Left_109/VGND
+ PHY_EDGE_ROW_41_Left_108/VPB VSUBS sky130_fd_sc_hd__decap_3
Xu_axi_slave__228_ VSUBS u_axi_slave__228_/VPB u_axi_slave__228_/VPB VSUBS u_axi_slave__228_/CLK
+ u_axi_slave__228_/D u_axi_slave__228_/RESET_B u_axi_slave__228_/Q sky130_fd_sc_hd__dfrtp_1
Xu_uart_tx__145_ VSUBS u_uart_tx__165_/VPB u_uart_tx__165_/VPB VSUBS u_uart_tx__145_/CLK
+ u_uart_tx__145_/D u_uart_tx__164_/RESET_B u_uart_tx__145_/Q sky130_fd_sc_hd__dfrtp_1
Xu_uart_tx__076_ u_uart_tx__091_/VGND u_uart_tx__142_/VPB u_uart_tx__142_/VPB VSUBS
+ u_uart_tx__076_/X u_uart_tx__076_/A1 u_uart_tx__076_/S u_uart_tx__076_/A0 sky130_fd_sc_hd__mux2_1
Xclkbuf_4_10_0_s_axi_aclk clkbuf_4_10_0_s_axi_aclk/X clkbuf_4_10_0_s_axi_aclk/A TAP_TAPCELL_ROW_21_293/VPWR
+ VSUBS VSUBS TAP_TAPCELL_ROW_21_293/VPWR sky130_fd_sc_hd__clkbuf_8
XPHY_EDGE_ROW_27_Right_27 PHY_EDGE_ROW_27_Right_27/VPWR PHY_EDGE_ROW_28_Right_28/VGND
+ PHY_EDGE_ROW_27_Right_27/VPB VSUBS sky130_fd_sc_hd__decap_3
XPHY_EDGE_ROW_18_Right_18 PHY_EDGE_ROW_19_Right_19/VPWR PHY_EDGE_ROW_18_Right_18/VGND
+ PHY_EDGE_ROW_19_Right_19/VPB VSUBS sky130_fd_sc_hd__decap_3
XPHY_EDGE_ROW_54_Right_54 PHY_EDGE_ROW_55_Right_55/VPWR PHY_EDGE_ROW_54_Right_54/VGND
+ PHY_EDGE_ROW_55_Right_55/VPB VSUBS sky130_fd_sc_hd__decap_3
XPHY_EDGE_ROW_45_Right_45 PHY_EDGE_ROW_45_Right_45/VPWR VSUBS PHY_EDGE_ROW_45_Right_45/VPB
+ VSUBS sky130_fd_sc_hd__decap_3
XPHY_EDGE_ROW_36_Right_36 PHY_EDGE_ROW_37_Right_37/VPWR PHY_EDGE_ROW_36_Right_36/VGND
+ PHY_EDGE_ROW_37_Right_37/VPB VSUBS sky130_fd_sc_hd__decap_3
Xu_uart_tx__128_ u_uart_tx__166_/VPB VSUBS u_uart_tx__166_/VPB VSUBS u_uart_tx__128_/A2
+ u_uart_tx__128_/A1 u_uart_tx__128_/B1 u_uart_tx__128_/Y sky130_fd_sc_hd__a21oi_1
XPHY_EDGE_ROW_63_Right_63 PHY_EDGE_ROW_63_Right_63/VPWR PHY_EDGE_ROW_64_Right_64/VGND
+ PHY_EDGE_ROW_63_Right_63/VPB VSUBS sky130_fd_sc_hd__decap_3
Xclkbuf_3_0__f_uart_clk VSUBS u_uart_tx__142_/VPB VSUBS u_uart_tx__142_/VPB clkbuf_3_0__f_uart_clk/A
+ clkbuf_3_0__f_uart_clk/X sky130_fd_sc_hd__clkbuf_16
Xu_async_fifo_fifomem__500_ u_async_fifo_fifomem__500_/Q u_async_fifo_fifomem__500_/CLK
+ u_async_fifo_fifomem__500_/D TAP_TAPCELL_ROW_47_474/VPWR VSUBS TAP_TAPCELL_ROW_47_474/VPWR
+ VSUBS sky130_fd_sc_hd__dfxtp_1
Xu_async_fifo_fifomem__362_ u_async_fifo_fifomem__491_/VGND TAP_TAPCELL_ROW_37_403/VPWR
+ TAP_TAPCELL_ROW_37_403/VPWR VSUBS u_async_fifo_fifomem__362_/X u_async_fifo_fifomem__362_/A1
+ u_async_fifo_fifomem__362_/S u_async_fifo_fifomem__362_/A0 sky130_fd_sc_hd__mux2_1
Xu_async_fifo_fifomem__293_ VSUBS u_async_fifo_fifomem__293_/VPWR u_async_fifo_fifomem__293_/VPB
+ VSUBS u_async_fifo_fifomem__293_/X u_async_fifo_fifomem__293_/A1 u_async_fifo_fifomem__293_/S
+ u_async_fifo_fifomem__293_/A0 sky130_fd_sc_hd__mux2_1
Xu_async_fifo_fifomem__431_ u_async_fifo_fifomem__431_/Q u_async_fifo_fifomem__431_/CLK
+ u_async_fifo_fifomem__431_/D TAP_TAPCELL_ROW_22_299/VPWR VSUBS TAP_TAPCELL_ROW_22_299/VPWR
+ VSUBS sky130_fd_sc_hd__dfxtp_1
Xu_async_fifo_fifomem__345_ VSUBS TAP_TAPCELL_ROW_51_500/VPWR TAP_TAPCELL_ROW_51_500/VPWR
+ VSUBS u_async_fifo_fifomem__345_/X u_async_fifo_fifomem__345_/A1 u_async_fifo_fifomem__345_/S
+ u_async_fifo_fifomem__345_/A0 sky130_fd_sc_hd__mux2_1
Xu_async_fifo_fifomem__414_ u_async_fifo_fifomem__414_/Q u_async_fifo_fifomem__414_/CLK
+ u_async_fifo_fifomem__414_/D u_async_fifo_fifomem__414_/VPB VSUBS u_async_fifo_fifomem__414_/VPWR
+ u_async_fifo_fifomem__414_/VGND sky130_fd_sc_hd__dfxtp_1
Xu_axi_slave__192_ VSUBS u_axi_slave__241_/VPB u_axi_slave__241_/VPB VSUBS u_axi_slave__192_/X
+ u_axi_slave__192_/A1 u_axi_slave__192_/S u_axi_slave__192_/A0 sky130_fd_sc_hd__mux2_1
Xu_async_fifo_fifomem__276_ TAP_TAPCELL_ROW_23_304/VPWR VSUBS VSUBS TAP_TAPCELL_ROW_23_304/VPWR
+ u_async_fifo_fifomem__276_/A u_async_fifo_fifomem__276_/Y u_async_fifo_fifomem__276_/B
+ sky130_fd_sc_hd__nand2_1
XPHY_EDGE_ROW_0_Right_0 PHY_EDGE_ROW_1_Right_1/VPWR PHY_EDGE_ROW_0_Right_0/VGND PHY_EDGE_ROW_1_Right_1/VPB
+ VSUBS sky130_fd_sc_hd__decap_3
Xu_axi_slave__175_ VSUBS u_axi_slave__224_/VPB u_axi_slave__224_/VPB VSUBS u_axi_slave__175_/X
+ u_axi_slave__175_/A1 u_axi_slave__175_/S u_axi_slave__175_/A0 sky130_fd_sc_hd__mux2_1
Xclkbuf_4_15_0_s_axi_aclk clkbuf_4_15_0_s_axi_aclk/X clkbuf_4_15_0_s_axi_aclk/A u_axi_slave__240_/VPB
+ VSUBS VSUBS u_axi_slave__240_/VPB sky130_fd_sc_hd__clkbuf_8
Xu_axi_slave__244_ VSUBS u_axi_slave__244_/VPB u_axi_slave__244_/VPB VSUBS u_axi_slave__244_/CLK
+ u_axi_slave__244_/D u_axi_slave__244_/RESET_B u_axi_slave__244_/Q sky130_fd_sc_hd__dfrtp_1
Xu_async_fifo_fifomem__259_ VSUBS TAP_TAPCELL_ROW_27_333/VPWR TAP_TAPCELL_ROW_27_333/VPWR
+ VSUBS u_async_fifo_fifomem__259_/X u_async_fifo_fifomem__259_/A1 u_async_fifo_fifomem__259_/S
+ u_async_fifo_fifomem__259_/A0 sky130_fd_sc_hd__mux2_1
Xu_async_fifo_fifomem__328_ u_async_fifo_fifomem__461_/VGND u_async_fifo_fifomem__328_/VPWR
+ u_async_fifo_fifomem__328_/VPB VSUBS u_async_fifo_fifomem__328_/X u_async_fifo_fifomem__328_/A1
+ u_async_fifo_fifomem__328_/S u_async_fifo_fifomem__328_/A0 sky130_fd_sc_hd__mux2_1
Xu_uart_tx__092_ u_uart_tx__092_/VPB VSUBS VSUBS u_uart_tx__092_/VPB u_uart_tx__092_/A
+ u_uart_tx__092_/B u_uart_tx__092_/Y sky130_fd_sc_hd__nor2_1
Xu_uart_tx__161_ VSUBS u_uart_tx__163_/VPB u_uart_tx__163_/VPB VSUBS u_uart_tx__161_/CLK
+ u_uart_tx__161_/D u_uart_tx__163_/RESET_B u_uart_tx__161_/Q sky130_fd_sc_hd__dfrtp_1
Xu_async_fifo_rptr_empty__36_ clkbuf_3_6__f_uart_clk/VPB VSUBS VSUBS clkbuf_3_6__f_uart_clk/VPB
+ u_async_fifo_rptr_empty__36_/Y u_async_fifo_rptr_empty__36_/D u_async_fifo_rptr_empty__36_/C
+ u_async_fifo_rptr_empty__36_/B u_async_fifo_rptr_empty__36_/A sky130_fd_sc_hd__nor4_1
Xu_axi_slave__227_ VSUBS u_axi_slave__227_/VPB u_axi_slave__227_/VPB VSUBS u_axi_slave__227_/CLK
+ u_axi_slave__227_/D u_axi_slave__227_/RESET_B u_axi_slave__227_/Q sky130_fd_sc_hd__dfrtp_1
Xu_axi_slave__158_ u_axi_slave__159_/VPB VSUBS VSUBS u_axi_slave__159_/VPB u_axi_slave__158_/C
+ u_axi_slave__158_/B u_axi_slave__158_/A u_axi_slave__158_/Y sky130_fd_sc_hd__nor3_1
Xu_uart_tx__144_ VSUBS u_uart_tx__166_/VPB u_uart_tx__166_/VPB VSUBS u_uart_tx__144_/CLK
+ u_uart_tx__144_/D u_uart_tx__144_/RESET_B u_uart_tx__144_/Q sky130_fd_sc_hd__dfrtp_1
Xu_uart_tx__075_ VSUBS _35_/VPB _35_/VPB VSUBS u_uart_tx__075_/X u_uart_tx__075_/A1
+ u_uart_tx__075_/S u_uart_tx__075_/A0 sky130_fd_sc_hd__mux2_1
Xu_async_fifo_rptr_empty__19_ clkbuf_3_3__f_uart_clk/VPB VSUBS VSUBS clkbuf_3_3__f_uart_clk/VPB
+ u_async_fifo_rptr_empty__19_/A u_async_fifo_rptr_empty__19_/Y sky130_fd_sc_hd__clkinv_1
Xu_uart_tx__127_ u_uart_tx__167_/VPB VSUBS u_uart_tx__167_/VPB VSUBS u_uart_tx__127_/A2
+ u_uart_tx__127_/A1 u_uart_tx__127_/B1 u_uart_tx__127_/Y sky130_fd_sc_hd__a21oi_1
Xu_async_fifo_fifomem__292_ u_async_fifo_fifomem__292_/VGND TAP_TAPCELL_ROW_51_501/VPWR
+ TAP_TAPCELL_ROW_51_501/VPWR VSUBS u_async_fifo_fifomem__292_/X u_async_fifo_fifomem__292_/A1
+ u_async_fifo_fifomem__292_/S u_async_fifo_fifomem__292_/A0 sky130_fd_sc_hd__mux2_1
Xu_async_fifo_fifomem__430_ u_async_fifo_fifomem__430_/Q u_async_fifo_fifomem__430_/CLK
+ u_async_fifo_fifomem__430_/D TAP_TAPCELL_ROW_51_501/VPWR VSUBS TAP_TAPCELL_ROW_51_501/VPWR
+ VSUBS sky130_fd_sc_hd__dfxtp_1
Xu_async_fifo_fifomem__361_ VSUBS TAP_TAPCELL_ROW_29_346/VPWR TAP_TAPCELL_ROW_29_346/VPWR
+ VSUBS u_async_fifo_fifomem__361_/X u_async_fifo_fifomem__361_/A1 u_async_fifo_fifomem__361_/S
+ u_async_fifo_fifomem__361_/A0 sky130_fd_sc_hd__mux2_1
Xu_async_fifo_wptr_full__47_ VSUBS TAP_TAPCELL_ROW_19_279/VPWR TAP_TAPCELL_ROW_19_279/VPWR
+ VSUBS u_async_fifo_wptr_full__47_/CLK u_async_fifo_wptr_full__47_/D u_async_fifo_wptr_full__47_/RESET_B
+ u_async_fifo_wptr_full__47_/Q sky130_fd_sc_hd__dfrtp_1
XPHY_EDGE_ROW_26_Left_93 PHY_EDGE_ROW_27_Left_94/VPWR PHY_EDGE_ROW_26_Left_93/VGND
+ PHY_EDGE_ROW_27_Left_94/VPB VSUBS sky130_fd_sc_hd__decap_3
XPHY_EDGE_ROW_10_Left_77 PHY_EDGE_ROW_11_Left_78/VPWR PHY_EDGE_ROW_9_Left_76/VGND
+ PHY_EDGE_ROW_11_Left_78/VPB VSUBS sky130_fd_sc_hd__decap_3
Xu_async_fifo_fifomem__275_ VSUBS clkbuf_4_4_0_s_axi_aclk/VPB clkbuf_4_4_0_s_axi_aclk/VPB
+ VSUBS u_async_fifo_fifomem__275_/X u_async_fifo_fifomem__275_/A1 u_async_fifo_fifomem__275_/S
+ u_async_fifo_fifomem__275_/A0 sky130_fd_sc_hd__mux2_1
Xu_axi_slave__191_ VSUBS u_axi_slave__233_/VPB u_axi_slave__233_/VPB VSUBS u_axi_slave__191_/X
+ u_axi_slave__191_/A1 u_axi_slave__191_/S u_axi_slave__191_/A0 sky130_fd_sc_hd__mux2_1
Xu_async_fifo_fifomem__344_ VSUBS TAP_TAPCELL_ROW_35_388/VPWR TAP_TAPCELL_ROW_35_388/VPWR
+ VSUBS u_async_fifo_fifomem__344_/X u_async_fifo_fifomem__344_/A1 u_async_fifo_fifomem__344_/S
+ u_async_fifo_fifomem__344_/A0 sky130_fd_sc_hd__mux2_1
Xu_async_fifo_fifomem__413_ u_async_fifo_fifomem__413_/Q u_async_fifo_fifomem__413_/CLK
+ u_async_fifo_fifomem__413_/D TAP_TAPCELL_ROW_17_262/VPWR VSUBS TAP_TAPCELL_ROW_17_262/VPWR
+ VSUBS sky130_fd_sc_hd__dfxtp_1
Xu_async_fifo_fifomem__327_ VSUBS TAP_TAPCELL_ROW_48_479/VPWR TAP_TAPCELL_ROW_48_479/VPWR
+ VSUBS u_async_fifo_fifomem__327_/X u_async_fifo_fifomem__327_/A1 u_async_fifo_fifomem__327_/S
+ u_async_fifo_fifomem__327_/A0 sky130_fd_sc_hd__mux2_1
Xu_axi_slave__174_ VSUBS ANTENNA_1/VPB ANTENNA_1/VPB VSUBS u_axi_slave__174_/X u_axi_slave__174_/A1
+ u_axi_slave__174_/S u_axi_slave__174_/A0 sky130_fd_sc_hd__mux2_1
Xu_async_fifo_fifomem__189_ VSUBS TAP_TAPCELL_ROW_29_346/VPWR VSUBS TAP_TAPCELL_ROW_29_346/VPWR
+ u_async_fifo_fifomem__189_/S0 u_async_fifo_fifomem__189_/A2 u_async_fifo_fifomem__189_/A3
+ u_async_fifo_fifomem__189_/S1 u_async_fifo_fifomem__189_/A1 u_async_fifo_fifomem__189_/A0
+ u_async_fifo_fifomem__189_/X sky130_fd_sc_hd__mux4_2
Xu_async_fifo_fifomem__258_ u_async_fifo_fifomem__315_/VPB VSUBS u_async_fifo_fifomem__370_/VGND
+ u_async_fifo_fifomem__315_/VPWR u_async_fifo_fifomem__258_/A u_async_fifo_fifomem__258_/B
+ u_async_fifo_fifomem__258_/Y u_async_fifo_fifomem__258_/C sky130_fd_sc_hd__nand3_1
Xu_axi_slave__243_ VSUBS u_axi_slave__243_/VPB u_axi_slave__243_/VPB VSUBS u_axi_slave__243_/CLK
+ u_axi_slave__243_/D u_axi_slave__243_/RESET_B u_axi_slave__243_/Q sky130_fd_sc_hd__dfrtp_1
Xu_uart_tx__160_ VSUBS u_uart_tx__167_/VPB u_uart_tx__167_/VPB VSUBS u_uart_tx__160_/CLK
+ u_uart_tx__160_/D u_uart_tx__160_/RESET_B u_uart_tx__160_/Q sky130_fd_sc_hd__dfrtp_1
Xu_async_fifo_rptr_empty__35_ clkbuf_3_3__f_uart_clk/VPB VSUBS u_async_fifo_rptr_empty__35_/VGND
+ clkbuf_3_3__f_uart_clk/VPB u_async_fifo_rptr_empty__35_/A_N u_async_fifo_rptr_empty__35_/B
+ u_async_fifo_rptr_empty__35_/Y sky130_fd_sc_hd__nand2b_1
Xu_uart_tx__091_ u_uart_tx__091_/VGND u_uart_tx__142_/VPB u_uart_tx__142_/VPB VSUBS
+ u_uart_tx__091_/X u_uart_tx__091_/A1 u_uart_tx__091_/S u_uart_tx__091_/A0 sky130_fd_sc_hd__mux2_1
Xu_axi_slave__157_ u_axi_slave__159_/VPB VSUBS VSUBS u_axi_slave__159_/VPB u_axi_slave__157_/A
+ u_axi_slave__157_/Y u_axi_slave__157_/B sky130_fd_sc_hd__nand2_1
Xu_axi_slave__226_ VSUBS u_axi_slave__233_/VPB u_axi_slave__233_/VPB VSUBS u_axi_slave__226_/CLK
+ u_axi_slave__226_/D u_axi_slave__226_/RESET_B u_axi_slave__226_/Q sky130_fd_sc_hd__dfrtp_1
XPHY_EDGE_ROW_13_Left_80 PHY_EDGE_ROW_13_Left_80/VPWR PHY_EDGE_ROW_14_Left_81/VGND
+ PHY_EDGE_ROW_13_Left_80/VPB VSUBS sky130_fd_sc_hd__decap_3
Xu_uart_tx__143_ VSUBS u_uart_tx__143_/VPB u_uart_tx__143_/VPB VSUBS u_uart_tx__143_/CLK
+ u_uart_tx__143_/D u_uart_tx__143_/RESET_B u_uart_tx__143_/Q sky130_fd_sc_hd__dfrtp_1
Xu_uart_tx__074_ VSUBS _28_/VPB _28_/VPB VSUBS u_uart_tx__074_/X u_uart_tx__074_/A1
+ u_uart_tx__074_/S u_uart_tx__074_/A0 sky130_fd_sc_hd__mux2_1
Xu_async_fifo_rptr_empty__18_ VSUBS _38_/VPB _38_/VPB VSUBS u_async_fifo_rptr_empty__18_/A
+ u_async_fifo_rptr_empty__18_/X u_async_fifo_rptr_empty__18_/B sky130_fd_sc_hd__xor2_1
Xu_axi_slave__209_ VSUBS u_axi_slave__209_/VPB u_axi_slave__209_/VPB VSUBS u_axi_slave__209_/CLK
+ u_axi_slave__209_/D u_axi_slave__209_/RESET_B u_axi_slave__209_/Q sky130_fd_sc_hd__dfrtp_1
Xu_uart_tx__126_ u_uart_tx__167_/VPB VSUBS VSUBS u_uart_tx__167_/VPB u_uart_tx__126_/A
+ u_uart_tx__126_/Y u_uart_tx__126_/B sky130_fd_sc_hd__nand2_1
XPHY_EDGE_ROW_38_Left_105 PHY_EDGE_ROW_39_Left_106/VPWR PHY_EDGE_ROW_38_Left_105/VGND
+ PHY_EDGE_ROW_39_Left_106/VPB VSUBS sky130_fd_sc_hd__decap_3
XPHY_EDGE_ROW_56_Left_123 PHY_EDGE_ROW_57_Left_124/VPWR PHY_EDGE_ROW_56_Left_123/VGND
+ PHY_EDGE_ROW_57_Left_124/VPB VSUBS sky130_fd_sc_hd__decap_3
XPHY_EDGE_ROW_47_Left_114 PHY_EDGE_ROW_47_Left_114/VPWR PHY_EDGE_ROW_48_Left_115/VGND
+ PHY_EDGE_ROW_47_Left_114/VPB VSUBS sky130_fd_sc_hd__decap_3
Xu_async_fifo_fifomem__291_ VSUBS load_slew1/VPB load_slew1/VPB VSUBS u_async_fifo_fifomem__291_/X
+ u_async_fifo_fifomem__291_/A1 u_async_fifo_fifomem__291_/S u_async_fifo_fifomem__291_/A0
+ sky130_fd_sc_hd__mux2_1
Xu_async_fifo_fifomem__360_ TAP_TAPCELL_ROW_24_312/VPWR VSUBS VSUBS TAP_TAPCELL_ROW_24_312/VPWR
+ u_async_fifo_fifomem__360_/A u_async_fifo_fifomem__360_/B u_async_fifo_fifomem__360_/Y
+ sky130_fd_sc_hd__nor2_1
Xu_async_fifo_wptr_full__46_ VSUBS u_axi_slave__217_/VPB u_axi_slave__217_/VPB VSUBS
+ u_async_fifo_wptr_full__46_/CLK u_async_fifo_wptr_full__46_/D u_async_fifo_wptr_full__46_/RESET_B
+ u_async_fifo_wptr_full__46_/Q sky130_fd_sc_hd__dfrtp_1
XPHY_EDGE_ROW_65_Left_132 PHY_EDGE_ROW_65_Left_132/VPWR PHY_EDGE_ROW_66_Left_133/VGND
+ PHY_EDGE_ROW_65_Left_132/VPB VSUBS sky130_fd_sc_hd__decap_3
Xu_async_fifo_fifomem__489_ u_async_fifo_fifomem__489_/Q u_async_fifo_fifomem__489_/CLK
+ u_async_fifo_fifomem__489_/D clkbuf_4_4_0_s_axi_aclk/VPB VSUBS clkbuf_4_4_0_s_axi_aclk/VPB
+ VSUBS sky130_fd_sc_hd__dfxtp_1
Xu_uart_tx__109_ u_uart_tx__152_/VPB VSUBS VSUBS u_uart_tx__152_/VPB u_uart_tx__109_/A
+ u_uart_tx__109_/B u_uart_tx__109_/Y sky130_fd_sc_hd__nor2_1
Xu_async_fifo_fifomem__412_ u_async_fifo_fifomem__412_/Q u_async_fifo_fifomem__412_/CLK
+ u_async_fifo_fifomem__412_/D TAP_TAPCELL_ROW_44_452/VPWR VSUBS TAP_TAPCELL_ROW_44_452/VPWR
+ VSUBS sky130_fd_sc_hd__dfxtp_1
Xu_async_fifo_fifomem__274_ VSUBS u_async_fifo_fifomem__274_/VPWR u_async_fifo_fifomem__274_/VPB
+ VSUBS u_async_fifo_fifomem__274_/X u_async_fifo_fifomem__274_/A1 u_async_fifo_fifomem__274_/S
+ u_async_fifo_fifomem__274_/A0 sky130_fd_sc_hd__mux2_1
Xu_axi_slave__190_ VSUBS ANTENNA_1/VPB ANTENNA_1/VPB VSUBS u_axi_slave__190_/X u_axi_slave__190_/A1
+ u_axi_slave__190_/S u_axi_slave__190_/A0 sky130_fd_sc_hd__mux2_1
Xu_async_fifo_fifomem__343_ u_async_fifo_fifomem__343_/VGND u_async_fifo_fifomem__474_/VPWR
+ u_async_fifo_fifomem__474_/VPB VSUBS u_async_fifo_fifomem__343_/X u_async_fifo_fifomem__343_/A1
+ u_async_fifo_fifomem__343_/S u_async_fifo_fifomem__343_/A0 sky130_fd_sc_hd__mux2_1
Xu_async_fifo_wptr_full__29_ VSUBS TAP_TAPCELL_ROW_21_293/VPWR VSUBS TAP_TAPCELL_ROW_21_293/VPWR
+ u_async_fifo_wptr_full__29_/X u_async_fifo_wptr_full__29_/C u_async_fifo_wptr_full__29_/B
+ u_async_fifo_wptr_full__29_/A sky130_fd_sc_hd__xnor3_1
Xu_axi_slave__242_ VSUBS u_axi_slave__242_/VPB u_axi_slave__242_/VPB VSUBS u_axi_slave__242_/CLK
+ u_axi_slave__242_/D u_axi_slave__242_/RESET_B u_axi_slave__242_/Q sky130_fd_sc_hd__dfrtp_1
Xu_async_fifo_fifomem__326_ VSUBS clkbuf_4_4_0_s_axi_aclk/VPB clkbuf_4_4_0_s_axi_aclk/VPB
+ VSUBS u_async_fifo_fifomem__326_/X u_async_fifo_fifomem__326_/A1 u_async_fifo_fifomem__326_/S
+ u_async_fifo_fifomem__326_/A0 sky130_fd_sc_hd__mux2_1
Xu_axi_slave__173_ VSUBS u_axi_slave__222_/VPB u_axi_slave__222_/VPB VSUBS u_axi_slave__173_/X
+ u_axi_slave__173_/A1 u_axi_slave__173_/S u_axi_slave__173_/A0 sky130_fd_sc_hd__mux2_1
Xu_async_fifo_fifomem__188_ VSUBS load_slew1/VPB VSUBS load_slew1/VPB u_async_fifo_fifomem__188_/S0
+ u_async_fifo_fifomem__188_/A2 u_async_fifo_fifomem__188_/A3 u_async_fifo_fifomem__188_/S1
+ u_async_fifo_fifomem__188_/A1 u_async_fifo_fifomem__188_/A0 u_async_fifo_fifomem__188_/X
+ sky130_fd_sc_hd__mux4_2
Xu_async_fifo_fifomem__257_ u_async_fifo_fifomem__257_/VPB VSUBS VSUBS u_async_fifo_fifomem__257_/VPWR
+ u_async_fifo_fifomem__257_/A u_async_fifo_fifomem__257_/B u_async_fifo_fifomem__257_/Y
+ sky130_fd_sc_hd__nor2_1
Xu_uart_tx__090_ u_uart_tx__167_/VPB VSUBS VSUBS u_uart_tx__167_/VPB u_uart_tx__090_/A
+ u_uart_tx__090_/SLEEP u_uart_tx__090_/X sky130_fd_sc_hd__lpflow_isobufsrc_1
Xu_async_fifo_rptr_empty__34_ VSUBS clkbuf_0_uart_clk/VPB clkbuf_0_uart_clk/VPB VSUBS
+ u_async_fifo_rptr_empty__34_/A u_async_fifo_rptr_empty__34_/X u_async_fifo_rptr_empty__34_/B
+ sky130_fd_sc_hd__xor2_1
Xu_async_fifo_fifomem__309_ u_async_fifo_fifomem__444_/VGND u_async_fifo_fifomem__309_/VPWR
+ u_async_fifo_fifomem__309_/VPB VSUBS u_async_fifo_fifomem__309_/X u_async_fifo_fifomem__309_/A1
+ u_async_fifo_fifomem__309_/S u_async_fifo_fifomem__309_/A0 sky130_fd_sc_hd__mux2_1
Xu_axi_slave__225_ VSUBS ANTENNA_2/VPB ANTENNA_2/VPB VSUBS u_axi_slave__225_/CLK u_axi_slave__225_/D
+ u_axi_slave__225_/RESET_B u_axi_slave__225_/Q sky130_fd_sc_hd__dfrtp_1
Xu_axi_slave__156_ u_axi_slave__159_/VPB VSUBS VSUBS u_axi_slave__159_/VPB u_axi_slave__156_/A1
+ u_axi_slave__156_/Y u_axi_slave__156_/C1 u_axi_slave__156_/B1 u_axi_slave__156_/A2
+ sky130_fd_sc_hd__o211ai_1
Xclkbuf_4_1_0_s_axi_aclk clkbuf_4_1_0_s_axi_aclk/X clkbuf_4_1_0_s_axi_aclk/A clkbuf_4_1_0_s_axi_aclk/VPB
+ VSUBS VSUBS clkbuf_4_1_0_s_axi_aclk/VPB sky130_fd_sc_hd__clkbuf_8
Xu_uart_tx__142_ VSUBS u_uart_tx__142_/VPB u_uart_tx__142_/VPB VSUBS u_uart_tx__142_/CLK
+ u_uart_tx__142_/D u_uart_tx__142_/RESET_B u_uart_tx__142_/Q sky130_fd_sc_hd__dfrtp_1
Xu_uart_tx__073_ u_uart_tx__091_/VGND u_uart_tx__137_/VPB u_uart_tx__137_/VPB VSUBS
+ u_uart_tx__073_/X u_uart_tx__073_/A1 u_uart_tx__073_/S u_uart_tx__073_/A0 sky130_fd_sc_hd__mux2_1
Xu_async_fifo_rptr_empty__17_ VSUBS _38_/VPB u_async_fifo_rptr_empty__17_/C u_async_fifo_rptr_empty__17_/A_N
+ u_async_fifo_rptr_empty__17_/X u_async_fifo_rptr_empty__17_/D u_async_fifo_rptr_empty__17_/B
+ _38_/VPB VSUBS sky130_fd_sc_hd__and4b_1
Xu_axi_slave__208_ VSUBS u_axi_slave__208_/VPB u_axi_slave__208_/VPB VSUBS u_axi_slave__208_/CLK
+ u_axi_slave__208_/D u_axi_slave__242_/RESET_B u_axi_slave__208_/Q sky130_fd_sc_hd__dfrtp_1
Xu_axi_slave__139_ u_axi_slave__230_/VPB VSUBS VSUBS u_axi_slave__230_/VPB u_axi_slave__139_/A
+ u_axi_slave__139_/Y u_axi_slave__139_/B sky130_fd_sc_hd__nand2_1
Xu_uart_tx__125_ u_uart_tx__167_/VPB VSUBS VSUBS u_uart_tx__167_/VPB u_uart_tx__125_/A
+ u_uart_tx__125_/B u_uart_tx__125_/Y sky130_fd_sc_hd__nor2_1
XPHY_EDGE_ROW_23_Right_23 PHY_EDGE_ROW_23_Right_23/VPWR PHY_EDGE_ROW_24_Right_24/VGND
+ PHY_EDGE_ROW_23_Right_23/VPB VSUBS sky130_fd_sc_hd__decap_3
Xu_async_fifo_sync_r2w__9_ VSUBS TAP_TAPCELL_ROW_15_251/VPWR TAP_TAPCELL_ROW_15_251/VPWR
+ VSUBS u_async_fifo_sync_r2w__9_/CLK u_async_fifo_sync_r2w__9_/D u_async_fifo_sync_r2w__9_/RESET_B
+ u_async_fifo_sync_r2w__9_/Q sky130_fd_sc_hd__dfrtp_1
XPHY_EDGE_ROW_14_Right_14 PHY_EDGE_ROW_15_Right_15/VPWR PHY_EDGE_ROW_14_Right_14/VGND
+ PHY_EDGE_ROW_15_Right_15/VPB VSUBS sky130_fd_sc_hd__decap_3
XPHY_EDGE_ROW_50_Right_50 PHY_EDGE_ROW_51_Right_51/VPWR PHY_EDGE_ROW_50_Right_50/VGND
+ PHY_EDGE_ROW_51_Right_51/VPB VSUBS sky130_fd_sc_hd__decap_3
XPHY_EDGE_ROW_41_Right_41 PHY_EDGE_ROW_41_Right_41/VPWR PHY_EDGE_ROW_42_Right_42/VGND
+ PHY_EDGE_ROW_41_Right_41/VPB VSUBS sky130_fd_sc_hd__decap_3
XPHY_EDGE_ROW_32_Right_32 PHY_EDGE_ROW_33_Right_33/VPWR PHY_EDGE_ROW_32_Right_32/VGND
+ PHY_EDGE_ROW_33_Right_33/VPB VSUBS sky130_fd_sc_hd__decap_3
Xu_async_fifo_wptr_full__45_ VSUBS TAP_TAPCELL_ROW_21_293/VPWR TAP_TAPCELL_ROW_21_293/VPWR
+ VSUBS u_async_fifo_wptr_full__45_/CLK u_async_fifo_wptr_full__45_/D u_async_fifo_wptr_full__45_/RESET_B
+ u_async_fifo_wptr_full__45_/Q sky130_fd_sc_hd__dfrtp_1
Xu_async_fifo_fifomem__290_ VSUBS TAP_TAPCELL_ROW_48_481/VPWR TAP_TAPCELL_ROW_48_481/VPWR
+ VSUBS u_async_fifo_fifomem__290_/X u_async_fifo_fifomem__290_/A1 u_async_fifo_fifomem__290_/S
+ u_async_fifo_fifomem__290_/A0 sky130_fd_sc_hd__mux2_1
Xu_async_fifo_fifomem__488_ u_async_fifo_fifomem__488_/Q u_async_fifo_fifomem__488_/CLK
+ u_async_fifo_fifomem__488_/D TAP_TAPCELL_ROW_34_380/VPWR VSUBS TAP_TAPCELL_ROW_34_380/VPWR
+ VSUBS sky130_fd_sc_hd__dfxtp_1
Xu_uart_tx__108_ u_uart_tx__152_/VPB VSUBS VSUBS u_uart_tx__152_/VPB u_uart_tx__108_/A
+ u_uart_tx__108_/B u_uart_tx__108_/Y sky130_fd_sc_hd__nor2_1
Xu_async_fifo_fifomem__411_ u_async_fifo_fifomem__411_/Q u_async_fifo_fifomem__411_/CLK
+ u_async_fifo_fifomem__411_/D TAP_TAPCELL_ROW_39_416/VPWR VSUBS TAP_TAPCELL_ROW_39_416/VPWR
+ VSUBS sky130_fd_sc_hd__dfxtp_1
Xu_async_fifo_fifomem__342_ TAP_TAPCELL_ROW_23_304/VPWR VSUBS VSUBS TAP_TAPCELL_ROW_23_304/VPWR
+ u_async_fifo_fifomem__342_/C u_async_fifo_fifomem__342_/B u_async_fifo_fifomem__342_/A
+ u_async_fifo_fifomem__342_/Y sky130_fd_sc_hd__nor3_1
Xu_async_fifo_wptr_full__28_ VSUBS u_axi_slave__217_/VPB u_async_fifo_wptr_full__28_/B
+ u_async_fifo_wptr_full__28_/Y u_async_fifo_wptr_full__28_/A u_axi_slave__217_/VPB
+ VSUBS sky130_fd_sc_hd__xnor2_1
Xu_async_fifo_fifomem__273_ VSUBS TAP_TAPCELL_ROW_19_275/VPWR TAP_TAPCELL_ROW_19_275/VPWR
+ VSUBS u_async_fifo_fifomem__273_/X u_async_fifo_fifomem__273_/A1 u_async_fifo_fifomem__273_/S
+ u_async_fifo_fifomem__273_/A0 sky130_fd_sc_hd__mux2_1
Xclkbuf_4_6_0_s_axi_aclk clkbuf_4_6_0_s_axi_aclk/X clkbuf_4_6_0_s_axi_aclk/A clkbuf_4_7_0_s_axi_aclk/VPB
+ VSUBS VSUBS clkbuf_4_7_0_s_axi_aclk/VPB sky130_fd_sc_hd__clkbuf_8
XPHY_EDGE_ROW_4_Right_4 PHY_EDGE_ROW_5_Right_5/VPWR PHY_EDGE_ROW_4_Right_4/VGND PHY_EDGE_ROW_5_Right_5/VPB
+ VSUBS sky130_fd_sc_hd__decap_3
Xu_axi_slave__241_ VSUBS u_axi_slave__241_/VPB u_axi_slave__241_/VPB VSUBS u_axi_slave__241_/CLK
+ u_axi_slave__241_/D u_axi_slave__241_/RESET_B u_axi_slave__241_/Q sky130_fd_sc_hd__dfrtp_1
Xu_async_fifo_fifomem__256_ VSUBS TAP_TAPCELL_ROW_39_417/VPWR TAP_TAPCELL_ROW_39_417/VPWR
+ VSUBS u_async_fifo_fifomem__256_/X u_async_fifo_fifomem__256_/A1 u_async_fifo_fifomem__256_/S
+ u_async_fifo_fifomem__256_/A0 sky130_fd_sc_hd__mux2_1
Xu_axi_slave__172_ VSUBS u_axi_slave__220_/VPB u_axi_slave__220_/VPB VSUBS u_axi_slave__172_/X
+ u_axi_slave__172_/A1 u_axi_slave__172_/S u_axi_slave__172_/A0 sky130_fd_sc_hd__mux2_1
Xu_async_fifo_fifomem__325_ VSUBS TAP_TAPCELL_ROW_31_359/VPWR TAP_TAPCELL_ROW_31_359/VPWR
+ VSUBS u_async_fifo_fifomem__325_/X u_async_fifo_fifomem__325_/A1 u_async_fifo_fifomem__325_/S
+ u_async_fifo_fifomem__325_/A0 sky130_fd_sc_hd__mux2_1
Xu_async_fifo_fifomem__187_ VSUBS TAP_TAPCELL_ROW_28_338/VPWR VSUBS TAP_TAPCELL_ROW_28_338/VPWR
+ u_async_fifo_fifomem__187_/S0 u_async_fifo_fifomem__187_/A2 u_async_fifo_fifomem__187_/A3
+ u_async_fifo_fifomem__187_/S1 u_async_fifo_fifomem__187_/A1 u_async_fifo_fifomem__187_/A0
+ u_async_fifo_fifomem__187_/X sky130_fd_sc_hd__mux4_2
Xu_async_fifo_rptr_empty__33_ VSUBS clkbuf_3_6__f_uart_clk/VPB clkbuf_3_6__f_uart_clk/VPB
+ VSUBS u_async_fifo_rptr_empty__33_/A u_async_fifo_rptr_empty__33_/X u_async_fifo_rptr_empty__33_/B
+ sky130_fd_sc_hd__xor2_1
Xu_axi_slave__155_ VSUBS u_axi_slave__224_/VPB u_axi_slave__224_/VPB VSUBS u_axi_slave__155_/X
+ u_axi_slave__155_/A3 u_axi_slave__155_/A2 u_axi_slave__155_/A1 u_axi_slave__155_/B1
+ u_axi_slave__155_/B2 sky130_fd_sc_hd__a32o_1
Xu_axi_slave__224_ VSUBS u_axi_slave__224_/VPB u_axi_slave__224_/VPB VSUBS u_axi_slave__224_/CLK
+ u_axi_slave__224_/D u_axi_slave__224_/RESET_B u_axi_slave__224_/Q sky130_fd_sc_hd__dfrtp_1
Xu_async_fifo_fifomem__239_ VSUBS TAP_TAPCELL_ROW_39_416/VPWR TAP_TAPCELL_ROW_39_416/VPWR
+ VSUBS u_async_fifo_fifomem__239_/X u_async_fifo_fifomem__239_/A1 u_async_fifo_fifomem__239_/S
+ u_async_fifo_fifomem__239_/A0 sky130_fd_sc_hd__mux2_1
Xu_async_fifo_fifomem__308_ VSUBS u_async_fifo_fifomem__308_/VPWR u_async_fifo_fifomem__308_/VPB
+ VSUBS u_async_fifo_fifomem__308_/X u_async_fifo_fifomem__308_/A1 u_async_fifo_fifomem__308_/S
+ u_async_fifo_fifomem__308_/A0 sky130_fd_sc_hd__mux2_1
Xu_async_fifo_rptr_empty__16_ _38_/VPB VSUBS VSUBS _38_/VPB u_async_fifo_rptr_empty__16_/Y
+ u_async_fifo_rptr_empty__16_/B u_async_fifo_rptr_empty__16_/C u_async_fifo_rptr_empty__16_/A_N
+ sky130_fd_sc_hd__nand3b_1
Xu_uart_tx__141_ VSUBS u_uart_tx__142_/VPB u_uart_tx__142_/VPB VSUBS u_uart_tx__141_/CLK
+ u_uart_tx__141_/D u_uart_tx__141_/RESET_B u_uart_tx__141_/Q sky130_fd_sc_hd__dfrtp_1
Xu_uart_tx__072_ _31_/VPB VSUBS VSUBS _31_/VPB u_uart_tx__072_/A u_uart_tx__072_/Y
+ u_uart_tx__072_/B sky130_fd_sc_hd__nand2_1
Xu_axi_slave__207_ VSUBS u_axi_slave__207_/VPB u_axi_slave__207_/VPB VSUBS u_axi_slave__207_/CLK
+ u_axi_slave__207_/D u_axi_slave__207_/RESET_B u_axi_slave__207_/Q sky130_fd_sc_hd__dfrtp_1
Xu_axi_slave__138_ u_axi_slave__240_/VPB u_axi_slave__138_/VGND u_axi_slave__240_/VPB
+ VSUBS u_axi_slave__138_/A2 u_axi_slave__138_/A1 u_axi_slave__138_/B1 u_axi_slave__138_/Y
+ sky130_fd_sc_hd__a21oi_1
Xu_uart_tx__124_ VSUBS u_uart_tx__124_/VPWR u_uart_tx__124_/B u_uart_tx__124_/Y u_uart_tx__124_/A
+ u_uart_tx__124_/VPB VSUBS sky130_fd_sc_hd__xnor2_1
Xu_async_fifo_sync_r2w__8_ VSUBS clkbuf_0_uart_clk/VPB clkbuf_0_uart_clk/VPB VSUBS
+ u_async_fifo_sync_r2w__8_/CLK u_async_fifo_sync_r2w__8_/D u_async_fifo_sync_r2w__8_/RESET_B
+ u_async_fifo_sync_r2w__8_/Q sky130_fd_sc_hd__dfrtp_1
Xu_async_fifo_wptr_full__44_ VSUBS u_axi_slave__217_/VPB u_axi_slave__217_/VPB VSUBS
+ u_async_fifo_wptr_full__44_/CLK u_async_fifo_wptr_full__44_/D u_async_fifo_wptr_full__44_/RESET_B
+ u_async_fifo_wptr_full__44_/Q sky130_fd_sc_hd__dfrtp_1
Xu_uart_tx__107_ VSUBS u_uart_tx__168_/VPB VSUBS u_uart_tx__168_/VPB u_uart_tx__107_/B1
+ u_uart_tx__107_/A1 u_uart_tx__107_/Y u_uart_tx__107_/A2 sky130_fd_sc_hd__o21ai_0
Xu_async_fifo_fifomem__487_ u_async_fifo_fifomem__487_/Q u_async_fifo_fifomem__487_/CLK
+ u_async_fifo_fifomem__487_/D TAP_TAPCELL_ROW_16_254/VPWR VSUBS TAP_TAPCELL_ROW_16_254/VPWR
+ VSUBS sky130_fd_sc_hd__dfxtp_1
Xu_async_fifo_fifomem__272_ VSUBS u_async_fifo_fifomem__414_/VPWR u_async_fifo_fifomem__414_/VPB
+ VSUBS u_async_fifo_fifomem__272_/X u_async_fifo_fifomem__272_/A1 u_async_fifo_fifomem__272_/S
+ u_async_fifo_fifomem__272_/A0 sky130_fd_sc_hd__mux2_1
Xu_async_fifo_fifomem__341_ VSUBS TAP_TAPCELL_ROW_36_394/VPWR TAP_TAPCELL_ROW_36_394/VPWR
+ VSUBS u_async_fifo_fifomem__341_/X u_async_fifo_fifomem__341_/A1 u_async_fifo_fifomem__341_/S
+ u_async_fifo_fifomem__341_/A0 sky130_fd_sc_hd__mux2_1
Xu_async_fifo_fifomem__410_ u_async_fifo_fifomem__410_/Q u_async_fifo_fifomem__410_/CLK
+ u_async_fifo_fifomem__410_/D u_async_fifo_fifomem__410_/VPB VSUBS u_async_fifo_fifomem__410_/VPWR
+ VSUBS sky130_fd_sc_hd__dfxtp_1
Xu_async_fifo_wptr_full__27_ VSUBS u_async_fifo__1_/VPB u_async_fifo_wptr_full__27_/B
+ u_async_fifo_wptr_full__27_/Y u_async_fifo_wptr_full__27_/A u_async_fifo__1_/VPB
+ VSUBS sky130_fd_sc_hd__xnor2_1
Xu_axi_slave__240_ VSUBS u_axi_slave__240_/VPB u_axi_slave__240_/VPB VSUBS u_axi_slave__240_/CLK
+ u_axi_slave__240_/D u_axi_slave__240_/RESET_B u_axi_slave__240_/Q sky130_fd_sc_hd__dfrtp_1
Xu_async_fifo_fifomem__255_ VSUBS TAP_TAPCELL_ROW_32_368/VPWR TAP_TAPCELL_ROW_32_368/VPWR
+ VSUBS u_async_fifo_fifomem__255_/X u_async_fifo_fifomem__255_/A1 u_async_fifo_fifomem__255_/S
+ u_async_fifo_fifomem__255_/A0 sky130_fd_sc_hd__mux2_1
Xu_axi_slave__171_ VSUBS u_axi_slave__220_/VPB u_axi_slave__220_/VPB VSUBS u_axi_slave__171_/X
+ u_axi_slave__171_/A1 u_axi_slave__171_/S u_axi_slave__171_/A0 sky130_fd_sc_hd__mux2_1
Xu_async_fifo_fifomem__186_ VSUBS clkbuf_4_3_0_s_axi_aclk/VPB VSUBS clkbuf_4_3_0_s_axi_aclk/VPB
+ u_async_fifo_fifomem__186_/S0 u_async_fifo_fifomem__186_/A2 u_async_fifo_fifomem__186_/A3
+ u_async_fifo_fifomem__186_/S1 u_async_fifo_fifomem__186_/A1 u_async_fifo_fifomem__186_/A0
+ u_async_fifo_fifomem__186_/X sky130_fd_sc_hd__mux4_2
Xu_async_fifo_fifomem__324_ TAP_TAPCELL_ROW_23_304/VPWR VSUBS VSUBS TAP_TAPCELL_ROW_23_304/VPWR
+ u_async_fifo_fifomem__324_/A u_async_fifo_fifomem__324_/B u_async_fifo_fifomem__324_/Y
+ sky130_fd_sc_hd__nor2_1
Xu_async_fifo_rptr_empty__32_ VSUBS clkbuf_3_6__f_uart_clk/VPB clkbuf_3_6__f_uart_clk/VPB
+ VSUBS u_async_fifo_rptr_empty__32_/A u_async_fifo_rptr_empty__32_/X u_async_fifo_rptr_empty__32_/B
+ sky130_fd_sc_hd__xor2_1
Xu_axi_slave__154_ VSUBS u_axi_slave__154_/VPB VSUBS u_axi_slave__154_/VPB u_axi_slave__154_/S0
+ u_axi_slave__154_/A2 u_axi_slave__154_/A3 u_axi_slave__154_/S1 u_axi_slave__154_/A1
+ u_axi_slave__154_/A0 u_axi_slave__154_/X sky130_fd_sc_hd__mux4_2
Xu_axi_slave__223_ VSUBS ANTENNA_2/VPB ANTENNA_2/VPB VSUBS u_axi_slave__223_/CLK u_axi_slave__223_/D
+ u_axi_slave__223_/RESET_B u_axi_slave__223_/Q sky130_fd_sc_hd__dfrtp_1
Xu_async_fifo_fifomem__238_ VSUBS TAP_TAPCELL_ROW_28_338/VPWR TAP_TAPCELL_ROW_28_338/VPWR
+ VSUBS u_async_fifo_fifomem__238_/X u_async_fifo_fifomem__238_/A1 u_async_fifo_fifomem__238_/S
+ u_async_fifo_fifomem__238_/A0 sky130_fd_sc_hd__mux2_1
Xu_async_fifo_fifomem__307_ u_async_fifo_fifomem__307_/VGND TAP_TAPCELL_ROW_27_331/VPWR
+ TAP_TAPCELL_ROW_27_331/VPWR VSUBS u_async_fifo_fifomem__307_/X u_async_fifo_fifomem__307_/A1
+ u_async_fifo_fifomem__307_/S u_async_fifo_fifomem__307_/A0 sky130_fd_sc_hd__mux2_1
Xu_uart_tx__071_ u_uart_tx__167_/VPB VSUBS VSUBS u_uart_tx__167_/VPB u_uart_tx__071_/A
+ u_uart_tx__071_/B u_uart_tx__071_/Y sky130_fd_sc_hd__nor2_1
Xu_uart_tx__140_ VSUBS u_uart_tx__142_/VPB u_uart_tx__142_/VPB VSUBS u_uart_tx__140_/CLK
+ u_uart_tx__140_/D u_uart_tx__141_/RESET_B u_uart_tx__140_/Q sky130_fd_sc_hd__dfrtp_1
Xu_async_fifo_rptr_empty__15_ clkbuf_3_3__f_uart_clk/VPB VSUBS VSUBS clkbuf_3_3__f_uart_clk/VPB
+ u_async_fifo_rptr_empty__15_/A_N u_async_fifo_rptr_empty__15_/B u_async_fifo_rptr_empty__15_/Y
+ sky130_fd_sc_hd__nand2b_1
XPHY_EDGE_ROW_17_Left_84 PHY_EDGE_ROW_17_Left_84/VPWR PHY_EDGE_ROW_18_Left_85/VGND
+ PHY_EDGE_ROW_17_Left_84/VPB VSUBS sky130_fd_sc_hd__decap_3
Xu_axi_slave__206_ VSUBS u_axi_slave__224_/VPB u_axi_slave__224_/VPB VSUBS u_axi_slave__206_/CLK
+ u_axi_slave__206_/D u_axi_slave__206_/RESET_B u_axi_slave__206_/Q sky130_fd_sc_hd__dfrtp_1
Xu_axi_slave__137_ VSUBS u_axi_slave__180_/VPB u_axi_slave__180_/VPB VSUBS u_axi_slave__137_/Y
+ u_axi_slave__137_/B1 u_axi_slave__137_/C1 u_axi_slave__137_/A1 u_axi_slave__137_/A2
+ u_axi_slave__137_/B2 sky130_fd_sc_hd__a221oi_1
Xu_uart_tx__123_ u_uart_tx__153_/VPB VSUBS VSUBS u_uart_tx__153_/VPB u_uart_tx__123_/A
+ u_uart_tx__123_/B u_uart_tx__123_/Y sky130_fd_sc_hd__nor2_1
XPHY_EDGE_ROW_2_Left_69 PHY_EDGE_ROW_3_Left_70/VPWR PHY_EDGE_ROW_2_Left_69/VGND PHY_EDGE_ROW_3_Left_70/VPB
+ VSUBS sky130_fd_sc_hd__decap_3
Xu_async_fifo_sync_r2w__7_ VSUBS TAP_TAPCELL_ROW_17_265/VPWR TAP_TAPCELL_ROW_17_265/VPWR
+ VSUBS u_async_fifo_sync_r2w__7_/CLK u_async_fifo_sync_r2w__7_/D u_async_fifo_sync_r2w__7_/RESET_B
+ u_async_fifo_sync_r2w__7_/Q sky130_fd_sc_hd__dfrtp_1
XPHY_EDGE_ROW_34_Left_101 PHY_EDGE_ROW_35_Left_102/VPWR PHY_EDGE_ROW_34_Left_101/VGND
+ PHY_EDGE_ROW_35_Left_102/VPB VSUBS sky130_fd_sc_hd__decap_3
Xu_uart_tx__106_ _31_/VPB VSUBS VSUBS _31_/VPB u_uart_tx__106_/A u_uart_tx__106_/B
+ u_uart_tx__106_/Y sky130_fd_sc_hd__nor2_1
Xu_async_fifo_wptr_full__43_ VSUBS TAP_TAPCELL_ROW_15_251/VPWR TAP_TAPCELL_ROW_15_251/VPWR
+ VSUBS u_async_fifo_wptr_full__43_/CLK u_async_fifo_wptr_full__43_/D u_async_fifo_wptr_full__43_/RESET_B
+ u_async_fifo_wptr_full__43_/Q sky130_fd_sc_hd__dfrtp_1
Xu_async_fifo_fifomem__486_ u_async_fifo_fifomem__486_/Q u_async_fifo_fifomem__486_/CLK
+ u_async_fifo_fifomem__486_/D TAP_TAPCELL_ROW_44_451/VPWR VSUBS TAP_TAPCELL_ROW_44_451/VPWR
+ VSUBS sky130_fd_sc_hd__dfxtp_1
XPHY_EDGE_ROW_43_Left_110 PHY_EDGE_ROW_43_Left_110/VPWR PHY_EDGE_ROW_44_Left_111/VGND
+ PHY_EDGE_ROW_43_Left_110/VPB VSUBS sky130_fd_sc_hd__decap_3
Xu_async_fifo_wptr_full__26_ VSUBS TAP_TAPCELL_ROW_19_279/VPWR VSUBS TAP_TAPCELL_ROW_19_279/VPWR
+ u_async_fifo_wptr_full__26_/X u_async_fifo_wptr_full__26_/C u_async_fifo_wptr_full__26_/B
+ u_async_fifo_wptr_full__26_/A sky130_fd_sc_hd__xnor3_1
X_39_ VSUBS _39_/VPB _39_/VPB VSUBS _39_/CLK _39_/D _39_/RESET_B _39_/Q sky130_fd_sc_hd__dfrtp_1
Xu_async_fifo_fifomem__340_ VSUBS TAP_TAPCELL_ROW_36_394/VPWR TAP_TAPCELL_ROW_36_394/VPWR
+ VSUBS u_async_fifo_fifomem__340_/X u_async_fifo_fifomem__340_/A1 u_async_fifo_fifomem__340_/S
+ u_async_fifo_fifomem__340_/A0 sky130_fd_sc_hd__mux2_1
Xu_async_fifo_fifomem__271_ VSUBS u_async_fifo_fifomem__348_/VPWR u_async_fifo_fifomem__348_/VPB
+ VSUBS u_async_fifo_fifomem__271_/X u_async_fifo_fifomem__271_/A1 u_async_fifo_fifomem__271_/S
+ u_async_fifo_fifomem__271_/A0 sky130_fd_sc_hd__mux2_1
XPHY_EDGE_ROW_5_Left_72 PHY_EDGE_ROW_5_Left_72/VPWR PHY_EDGE_ROW_6_Left_73/VGND PHY_EDGE_ROW_5_Left_72/VPB
+ VSUBS sky130_fd_sc_hd__decap_3
Xu_async_fifo_fifomem__469_ u_async_fifo_fifomem__469_/Q u_async_fifo_fifomem__469_/CLK
+ u_async_fifo_fifomem__469_/D TAP_TAPCELL_ROW_17_262/VPWR VSUBS TAP_TAPCELL_ROW_17_262/VPWR
+ u_async_fifo_fifomem__469_/VGND sky130_fd_sc_hd__dfxtp_1
Xu_async_fifo_fifomem__323_ VSUBS TAP_TAPCELL_ROW_43_446/VPWR TAP_TAPCELL_ROW_43_446/VPWR
+ VSUBS u_async_fifo_fifomem__323_/X u_async_fifo_fifomem__323_/A1 u_async_fifo_fifomem__323_/S
+ u_async_fifo_fifomem__323_/A0 sky130_fd_sc_hd__mux2_1
Xu_axi_slave__170_ VSUBS u_axi_slave__237_/VPB u_axi_slave__237_/VPB VSUBS u_axi_slave__170_/X
+ u_axi_slave__170_/A1 u_axi_slave__170_/S u_axi_slave__170_/A0 sky130_fd_sc_hd__mux2_1
Xu_async_fifo_fifomem__185_ VSUBS clkbuf_4_1_0_s_axi_aclk/VPB VSUBS clkbuf_4_1_0_s_axi_aclk/VPB
+ u_async_fifo_fifomem__185_/S0 u_async_fifo_fifomem__185_/A2 u_async_fifo_fifomem__185_/A3
+ u_async_fifo_fifomem__185_/S1 u_async_fifo_fifomem__185_/A1 u_async_fifo_fifomem__185_/A0
+ u_async_fifo_fifomem__185_/X sky130_fd_sc_hd__mux4_2
Xu_async_fifo_fifomem__254_ VSUBS TAP_TAPCELL_ROW_19_276/VPWR TAP_TAPCELL_ROW_19_276/VPWR
+ VSUBS u_async_fifo_fifomem__254_/X u_async_fifo_fifomem__254_/A1 u_async_fifo_fifomem__254_/S
+ u_async_fifo_fifomem__254_/A0 sky130_fd_sc_hd__mux2_1
XPHY_EDGE_ROW_31_Left_98 PHY_EDGE_ROW_31_Left_98/VPWR PHY_EDGE_ROW_32_Left_99/VGND
+ PHY_EDGE_ROW_31_Left_98/VPB VSUBS sky130_fd_sc_hd__decap_3
Xu_async_fifo_rptr_empty__31_ u_async_fifo_rptr_empty__31_/VGND TAP_TAPCELL_ROW_15_250/VPWR
+ u_async_fifo_rptr_empty__31_/X u_async_fifo_rptr_empty__31_/B u_async_fifo_rptr_empty__31_/A
+ u_async_fifo_rptr_empty__31_/C TAP_TAPCELL_ROW_15_250/VPWR VSUBS sky130_fd_sc_hd__and3_1
Xu_axi_slave__153_ u_axi_slave__153_/VGND u_axi_slave__205_/VPB u_axi_slave__205_/VPB
+ VSUBS u_axi_slave__153_/A3 u_axi_slave__153_/A2 u_axi_slave__153_/A1 u_axi_slave__153_/Y
+ u_axi_slave__153_/B1 sky130_fd_sc_hd__a31oi_1
Xu_axi_slave__222_ VSUBS u_axi_slave__222_/VPB u_axi_slave__222_/VPB VSUBS u_axi_slave__222_/CLK
+ u_axi_slave__222_/D u_axi_slave__222_/RESET_B u_axi_slave__222_/Q sky130_fd_sc_hd__dfrtp_1
Xu_async_fifo_fifomem__306_ TAP_TAPCELL_ROW_24_312/VPWR VSUBS VSUBS TAP_TAPCELL_ROW_24_312/VPWR
+ u_async_fifo_fifomem__306_/A u_async_fifo_fifomem__306_/B u_async_fifo_fifomem__306_/Y
+ sky130_fd_sc_hd__nor2_1
Xu_async_fifo_fifomem__237_ TAP_TAPCELL_ROW_24_312/VPWR VSUBS VSUBS TAP_TAPCELL_ROW_24_312/VPWR
+ u_async_fifo_fifomem__237_/A u_async_fifo_fifomem__237_/B u_async_fifo_fifomem__237_/Y
+ sky130_fd_sc_hd__nor2_1
Xu_uart_tx__070_ u_uart_tx__165_/VPB VSUBS VSUBS u_uart_tx__165_/VPB u_uart_tx__070_/A
+ u_uart_tx__070_/Y sky130_fd_sc_hd__clkinv_1
Xu_async_fifo_rptr_empty__14_ _38_/VPB VSUBS VSUBS _38_/VPB u_async_fifo_rptr_empty__14_/A
+ u_async_fifo_rptr_empty__14_/Y sky130_fd_sc_hd__clkinv_1
Xu_axi_slave__205_ VSUBS u_axi_slave__205_/VPB u_axi_slave__205_/VPB VSUBS u_axi_slave__205_/CLK
+ u_axi_slave__205_/D u_axi_slave__205_/RESET_B u_axi_slave__205_/Q sky130_fd_sc_hd__dfrtp_1
Xu_axi_slave__136_ u_axi_slave__136_/VPWR u_axi_slave__138_/VGND u_axi_slave__136_/VPB
+ VSUBS u_axi_slave__136_/A2 u_axi_slave__136_/A1 u_axi_slave__136_/B1 u_axi_slave__136_/Y
+ sky130_fd_sc_hd__a21oi_1
Xu_uart_tx__122_ VSUBS u_uart_tx__153_/VPB u_uart_tx__153_/VPB u_uart_tx__122_/VGND
+ u_uart_tx__122_/A u_uart_tx__122_/X u_uart_tx__122_/B sky130_fd_sc_hd__xor2_1
Xu_async_fifo_sync_r2w__6_ VSUBS clkbuf_0_uart_clk/VPB clkbuf_0_uart_clk/VPB VSUBS
+ u_async_fifo_sync_r2w__6_/CLK u_async_fifo_sync_r2w__6_/D u_async_fifo_sync_r2w__6_/RESET_B
+ u_async_fifo_sync_r2w__6_/Q sky130_fd_sc_hd__dfrtp_1
Xu_axi_slave__119_ VSUBS u_axi_slave__244_/VPB u_axi_slave__119_/X u_axi_slave__119_/B
+ u_axi_slave__119_/A u_axi_slave__119_/C u_axi_slave__244_/VPB VSUBS sky130_fd_sc_hd__and3_1
Xu_uart_tx__105_ VSUBS u_uart_tx__168_/VPB u_uart_tx__168_/VPB VSUBS u_uart_tx__105_/A3
+ u_uart_tx__105_/A2 u_uart_tx__105_/A1 u_uart_tx__105_/Y u_uart_tx__105_/B1 sky130_fd_sc_hd__a31oi_1
XPHY_EDGE_ROW_10_Right_10 PHY_EDGE_ROW_11_Right_11/VPWR PHY_EDGE_ROW_9_Right_9/VGND
+ PHY_EDGE_ROW_11_Right_11/VPB VSUBS sky130_fd_sc_hd__decap_3
Xu_async_fifo_wptr_full__42_ VSUBS clkbuf_3_6__f_uart_clk/VPB clkbuf_3_6__f_uart_clk/VPB
+ VSUBS u_async_fifo_wptr_full__42_/CLK u_async_fifo_wptr_full__42_/D u_async_fifo_wptr_full__42_/RESET_B
+ u_async_fifo_wptr_full__42_/Q sky130_fd_sc_hd__dfrtp_1
Xu_async_fifo_fifomem__485_ u_async_fifo_fifomem__485_/Q u_async_fifo_fifomem__485_/CLK
+ u_async_fifo_fifomem__485_/D TAP_TAPCELL_ROW_17_262/VPWR VSUBS TAP_TAPCELL_ROW_17_262/VPWR
+ VSUBS sky130_fd_sc_hd__dfxtp_1
Xu_async_fifo_fifomem__270_ VSUBS clkbuf_4_7_0_s_axi_aclk/VPB clkbuf_4_7_0_s_axi_aclk/VPB
+ VSUBS u_async_fifo_fifomem__270_/X u_async_fifo_fifomem__270_/A1 u_async_fifo_fifomem__270_/S
+ u_async_fifo_fifomem__270_/A0 sky130_fd_sc_hd__mux2_1
X_38_ VSUBS _38_/VPB _38_/VPB VSUBS _38_/CLK _38_/D _38_/RESET_B _38_/Q sky130_fd_sc_hd__dfrtp_1
Xu_async_fifo_wptr_full__25_ VSUBS TAP_TAPCELL_ROW_17_265/VPWR u_async_fifo_wptr_full__25_/B
+ u_async_fifo_wptr_full__25_/Y u_async_fifo_wptr_full__25_/A TAP_TAPCELL_ROW_17_265/VPWR
+ VSUBS sky130_fd_sc_hd__xnor2_1
Xu_async_fifo_fifomem__468_ u_async_fifo_fifomem__468_/Q u_async_fifo_fifomem__468_/CLK
+ u_async_fifo_fifomem__468_/D TAP_TAPCELL_ROW_45_458/VPWR VSUBS TAP_TAPCELL_ROW_45_458/VPWR
+ VSUBS sky130_fd_sc_hd__dfxtp_1
Xu_async_fifo_fifomem__399_ u_async_fifo_fifomem__399_/Q u_async_fifo_fifomem__399_/CLK
+ u_async_fifo_fifomem__399_/D TAP_TAPCELL_ROW_21_290/VPWR VSUBS TAP_TAPCELL_ROW_21_290/VPWR
+ VSUBS sky130_fd_sc_hd__dfxtp_1
XPHY_EDGE_ROW_62_Left_129 PHY_EDGE_ROW_63_Left_130/VPWR PHY_EDGE_ROW_62_Left_129/VGND
+ PHY_EDGE_ROW_63_Left_130/VPB VSUBS sky130_fd_sc_hd__decap_3
Xu_async_fifo_fifomem__322_ VSUBS TAP_TAPCELL_ROW_32_369/VPWR TAP_TAPCELL_ROW_32_369/VPWR
+ VSUBS u_async_fifo_fifomem__322_/X u_async_fifo_fifomem__322_/A1 u_async_fifo_fifomem__322_/S
+ u_async_fifo_fifomem__322_/A0 sky130_fd_sc_hd__mux2_1
Xu_async_fifo_fifomem__253_ VSUBS TAP_TAPCELL_ROW_51_500/VPWR TAP_TAPCELL_ROW_51_500/VPWR
+ VSUBS u_async_fifo_fifomem__253_/X u_async_fifo_fifomem__253_/A1 u_async_fifo_fifomem__253_/S
+ u_async_fifo_fifomem__253_/A0 sky130_fd_sc_hd__mux2_1
Xu_async_fifo_rptr_empty__30_ VSUBS clkbuf_0_uart_clk/VPB clkbuf_0_uart_clk/VPB VSUBS
+ u_async_fifo_rptr_empty__30_/A u_async_fifo_rptr_empty__30_/X u_async_fifo_rptr_empty__30_/B
+ sky130_fd_sc_hd__xor2_1
XPHY_EDGE_ROW_8_Right_8 PHY_EDGE_ROW_9_Right_9/VPWR PHY_EDGE_ROW_8_Right_8/VGND PHY_EDGE_ROW_9_Right_9/VPB
+ VSUBS sky130_fd_sc_hd__decap_3
XPHY_EDGE_ROW_57_Right_57 PHY_EDGE_ROW_57_Right_57/VPWR PHY_EDGE_ROW_58_Right_58/VGND
+ PHY_EDGE_ROW_57_Right_57/VPB VSUBS sky130_fd_sc_hd__decap_3
XPHY_EDGE_ROW_48_Right_48 PHY_EDGE_ROW_49_Right_49/VPWR PHY_EDGE_ROW_48_Right_48/VGND
+ PHY_EDGE_ROW_49_Right_49/VPB VSUBS sky130_fd_sc_hd__decap_3
Xu_async_fifo_fifomem__305_ VSUBS clkbuf_4_7_0_s_axi_aclk/VPB clkbuf_4_7_0_s_axi_aclk/VPB
+ VSUBS u_async_fifo_fifomem__305_/X u_async_fifo_fifomem__305_/A1 u_async_fifo_fifomem__305_/S
+ u_async_fifo_fifomem__305_/A0 sky130_fd_sc_hd__mux2_1
XPHY_EDGE_ROW_39_Right_39 PHY_EDGE_ROW_39_Right_39/VPWR PHY_EDGE_ROW_40_Right_40/VGND
+ PHY_EDGE_ROW_39_Right_39/VPB VSUBS sky130_fd_sc_hd__decap_3
Xu_axi_slave__152_ u_axi_slave__205_/VPB VSUBS u_axi_slave__153_/VGND u_axi_slave__205_/VPB
+ u_axi_slave__152_/A u_axi_slave__152_/B u_axi_slave__152_/Y sky130_fd_sc_hd__nor2_1
Xu_axi_slave__221_ VSUBS u_axi_slave__221_/VPB u_axi_slave__221_/VPB VSUBS u_axi_slave__221_/CLK
+ u_axi_slave__221_/D u_axi_slave__221_/RESET_B u_axi_slave__221_/Q sky130_fd_sc_hd__dfrtp_1
Xu_async_fifo_fifomem__236_ u_async_fifo_fifomem__315_/VPB VSUBS VSUBS u_async_fifo_fifomem__315_/VPWR
+ u_async_fifo_fifomem__236_/Y u_async_fifo_fifomem__236_/B u_async_fifo_fifomem__236_/C
+ u_async_fifo_fifomem__236_/A_N sky130_fd_sc_hd__nand3b_1
XPHY_EDGE_ROW_66_Right_66 PHY_EDGE_ROW_66_Right_66/VPWR PHY_EDGE_ROW_66_Right_66/VGND
+ PHY_EDGE_ROW_66_Right_66/VPB VSUBS sky130_fd_sc_hd__decap_3
Xu_axi_slave__135_ u_axi_slave__240_/VPB VSUBS VSUBS u_axi_slave__240_/VPB u_axi_slave__135_/A
+ u_axi_slave__135_/B u_axi_slave__135_/Y sky130_fd_sc_hd__nor2_1
Xu_async_fifo_fifomem__219_ VSUBS TAP_TAPCELL_ROW_33_374/VPWR VSUBS TAP_TAPCELL_ROW_33_374/VPWR
+ u_async_fifo_fifomem__219_/S0 u_async_fifo_fifomem__219_/A2 u_async_fifo_fifomem__219_/A3
+ u_async_fifo_fifomem__219_/S1 u_async_fifo_fifomem__219_/A1 u_async_fifo_fifomem__219_/A0
+ u_async_fifo_fifomem__219_/X sky130_fd_sc_hd__mux4_2
Xu_axi_slave__204_ VSUBS u_axi_slave__204_/VPB u_axi_slave__204_/VPB VSUBS u_axi_slave__204_/CLK
+ u_axi_slave__204_/D u_axi_slave__204_/RESET_B u_axi_slave__204_/Q sky130_fd_sc_hd__dfrtp_1
Xu_uart_tx__121_ u_uart_tx__152_/VPB VSUBS VSUBS u_uart_tx__152_/VPB u_uart_tx__121_/A
+ u_uart_tx__121_/B u_uart_tx__121_/Y u_uart_tx__121_/C sky130_fd_sc_hd__nand3_1
Xu_async_fifo_sync_r2w__5_ VSUBS TAP_TAPCELL_ROW_19_279/VPWR TAP_TAPCELL_ROW_19_279/VPWR
+ VSUBS u_async_fifo_sync_r2w__5_/CLK u_async_fifo_sync_r2w__5_/D u_async_fifo_sync_r2w__5_/RESET_B
+ u_async_fifo_sync_r2w__5_/Q sky130_fd_sc_hd__dfrtp_1
Xu_axi_slave__118_ VSUBS ANTENNA_1/VPB ANTENNA_1/VPB VSUBS u_axi_slave__118_/A3 u_axi_slave__118_/A2
+ u_axi_slave__118_/A1 u_axi_slave__118_/Y u_axi_slave__118_/B1 sky130_fd_sc_hd__a31oi_1
Xu_async_fifo_wptr_full__41_ VSUBS TAP_TAPCELL_ROW_19_279/VPWR TAP_TAPCELL_ROW_19_279/VPWR
+ VSUBS u_async_fifo_wptr_full__41_/CLK u_async_fifo_wptr_full__41_/D u_async_fifo_wptr_full__41_/RESET_B
+ u_async_fifo_wptr_full__41_/Q sky130_fd_sc_hd__dfrtp_1
Xu_uart_tx__104_ u_uart_tx__167_/VPB VSUBS VSUBS u_uart_tx__167_/VPB u_uart_tx__104_/A
+ u_uart_tx__104_/Y u_uart_tx__104_/B sky130_fd_sc_hd__nand2_1
Xu_async_fifo_fifomem__484_ u_async_fifo_fifomem__484_/Q u_async_fifo_fifomem__484_/CLK
+ u_async_fifo_fifomem__484_/D u_async_fifo_fifomem__484_/VPB VSUBS u_async_fifo_fifomem__484_/VPWR
+ VSUBS sky130_fd_sc_hd__dfxtp_1
Xclkbuf_4_11_0_s_axi_aclk clkbuf_4_11_0_s_axi_aclk/X clkbuf_4_11_0_s_axi_aclk/A u_axi_slave__217_/VPB
+ VSUBS VSUBS u_axi_slave__217_/VPB sky130_fd_sc_hd__clkbuf_8
X_37_ VSUBS _37_/VPB _37_/VPB VSUBS _37_/CLK _37_/D _37_/RESET_B _37_/Q sky130_fd_sc_hd__dfrtp_1
Xu_async_fifo_wptr_full__24_ TAP_TAPCELL_ROW_17_265/VPWR VSUBS VSUBS TAP_TAPCELL_ROW_17_265/VPWR
+ u_async_fifo_wptr_full__24_/A u_async_fifo_wptr_full__24_/B u_async_fifo_wptr_full__24_/Y
+ u_async_fifo_wptr_full__24_/C sky130_fd_sc_hd__nand3_1
Xu_async_fifo_fifomem__398_ u_async_fifo_fifomem__398_/Q u_async_fifo_fifomem__398_/CLK
+ u_async_fifo_fifomem__398_/D TAP_TAPCELL_ROW_53_514/VPWR VSUBS TAP_TAPCELL_ROW_53_514/VPWR
+ VSUBS sky130_fd_sc_hd__dfxtp_1
Xu_async_fifo_fifomem__467_ u_async_fifo_fifomem__467_/Q u_async_fifo_fifomem__467_/CLK
+ u_async_fifo_fifomem__467_/D TAP_TAPCELL_ROW_37_402/VPWR VSUBS TAP_TAPCELL_ROW_37_402/VPWR
+ VSUBS sky130_fd_sc_hd__dfxtp_1
Xu_async_fifo_fifomem__321_ u_async_fifo_fifomem__321_/VGND TAP_TAPCELL_ROW_25_319/VPWR
+ TAP_TAPCELL_ROW_25_319/VPWR VSUBS u_async_fifo_fifomem__321_/X u_async_fifo_fifomem__321_/A1
+ u_async_fifo_fifomem__321_/S u_async_fifo_fifomem__321_/A0 sky130_fd_sc_hd__mux2_1
Xu_async_fifo_fifomem__252_ VSUBS TAP_TAPCELL_ROW_19_277/VPWR TAP_TAPCELL_ROW_19_277/VPWR
+ VSUBS u_async_fifo_fifomem__252_/X u_async_fifo_fifomem__252_/A1 u_async_fifo_fifomem__252_/S
+ u_async_fifo_fifomem__252_/A0 sky130_fd_sc_hd__mux2_1
Xu_axi_slave__151_ u_axi_slave__224_/VPB VSUBS u_axi_slave__224_/VPB VSUBS u_axi_slave__151_/A2
+ u_axi_slave__151_/A1 u_axi_slave__151_/B1 u_axi_slave__151_/Y sky130_fd_sc_hd__a21oi_1
Xu_async_fifo_fifomem__304_ u_async_fifo_fifomem__304_/VGND TAP_TAPCELL_ROW_33_374/VPWR
+ TAP_TAPCELL_ROW_33_374/VPWR VSUBS u_async_fifo_fifomem__304_/X u_async_fifo_fifomem__304_/A1
+ u_async_fifo_fifomem__304_/S u_async_fifo_fifomem__304_/A0 sky130_fd_sc_hd__mux2_1
Xu_axi_slave__220_ VSUBS u_axi_slave__220_/VPB u_axi_slave__220_/VPB VSUBS u_axi_slave__220_/CLK
+ u_axi_slave__220_/D u_axi_slave__220_/RESET_B u_axi_slave__220_/Q sky130_fd_sc_hd__dfrtp_1
Xu_async_fifo_fifomem__235_ TAP_TAPCELL_ROW_23_304/VPWR VSUBS VSUBS TAP_TAPCELL_ROW_23_304/VPWR
+ u_async_fifo_fifomem__235_/A u_async_fifo_fifomem__235_/Y u_async_fifo_fifomem__235_/B
+ sky130_fd_sc_hd__nand2_1
Xu_axi_slave__134_ u_axi_slave__134_/VGND u_axi_slave__237_/VPB u_axi_slave__134_/X
+ u_axi_slave__134_/B u_axi_slave__134_/A u_axi_slave__134_/C u_axi_slave__237_/VPB
+ VSUBS sky130_fd_sc_hd__and3_1
Xu_async_fifo_fifomem__218_ VSUBS clkbuf_0_s_axi_aclk/VPB VSUBS clkbuf_0_s_axi_aclk/VPB
+ u_async_fifo_fifomem__218_/S0 u_async_fifo_fifomem__218_/A2 u_async_fifo_fifomem__218_/A3
+ u_async_fifo_fifomem__218_/S1 u_async_fifo_fifomem__218_/A1 u_async_fifo_fifomem__218_/A0
+ u_async_fifo_fifomem__218_/X sky130_fd_sc_hd__mux4_2
Xu_axi_slave__203_ VSUBS u_async_fifo__1_/VPB u_async_fifo__1_/VPB VSUBS u_axi_slave__203_/CLK
+ u_axi_slave__203_/D u_axi_slave__203_/RESET_B u_axi_slave__203_/Q sky130_fd_sc_hd__dfrtp_1
Xu_uart_tx__120_ u_uart_tx__153_/VPB VSUBS VSUBS u_uart_tx__153_/VPB u_uart_tx__120_/A
+ u_uart_tx__120_/B u_uart_tx__120_/Y sky130_fd_sc_hd__nor2_1
Xu_async_fifo_sync_r2w__4_ VSUBS TAP_TAPCELL_ROW_15_251/VPWR TAP_TAPCELL_ROW_15_251/VPWR
+ VSUBS u_async_fifo_sync_r2w__4_/CLK u_async_fifo_sync_r2w__4_/D u_async_fifo_sync_r2w__9_/RESET_B
+ u_async_fifo_sync_r2w__4_/Q sky130_fd_sc_hd__dfrtp_1
Xu_axi_slave__117_ VSUBS u_axi_slave__220_/VPB u_axi_slave__220_/VPB VSUBS u_axi_slave__117_/Y
+ u_axi_slave__117_/B1 u_axi_slave__117_/C1 u_axi_slave__117_/A1 u_axi_slave__117_/A2
+ u_axi_slave__117_/B2 sky130_fd_sc_hd__a221oi_1
Xu_async_fifo_wptr_full__40_ VSUBS TAP_TAPCELL_ROW_9_209/VPWR TAP_TAPCELL_ROW_9_209/VPWR
+ VSUBS u_async_fifo_wptr_full__40_/CLK u_async_fifo_wptr_full__40_/D u_async_fifo_wptr_full__40_/RESET_B
+ u_async_fifo_wptr_full__40_/Q sky130_fd_sc_hd__dfrtp_1
Xu_async_fifo_fifomem__483_ u_async_fifo_fifomem__483_/Q u_async_fifo_fifomem__483_/CLK
+ u_async_fifo_fifomem__483_/D TAP_TAPCELL_ROW_35_388/VPWR VSUBS TAP_TAPCELL_ROW_35_388/VPWR
+ VSUBS sky130_fd_sc_hd__dfxtp_1
Xu_uart_tx__103_ VSUBS u_uart_tx__167_/VPB VSUBS u_uart_tx__167_/VPB u_uart_tx__103_/B1
+ u_uart_tx__103_/A1 u_uart_tx__103_/Y u_uart_tx__103_/A2 sky130_fd_sc_hd__o21ai_0
X_36_ VSUBS _39_/VPB _39_/VPB VSUBS _36_/CLK _36_/D _39_/RESET_B _36_/Q sky130_fd_sc_hd__dfrtp_1
Xu_async_fifo_wptr_full__23_ VSUBS TAP_TAPCELL_ROW_15_251/VPWR u_async_fifo_wptr_full__23_/B
+ u_async_fifo_wptr_full__23_/Y u_async_fifo_wptr_full__23_/A TAP_TAPCELL_ROW_15_251/VPWR
+ VSUBS sky130_fd_sc_hd__xnor2_1
Xu_async_fifo_fifomem__466_ u_async_fifo_fifomem__466_/Q u_async_fifo_fifomem__466_/CLK
+ u_async_fifo_fifomem__466_/D u_async_fifo_fifomem__466_/VPB VSUBS u_async_fifo_fifomem__466_/VPWR
+ u_async_fifo_fifomem__466_/VGND sky130_fd_sc_hd__dfxtp_1
Xu_async_fifo_fifomem__397_ u_async_fifo_fifomem__397_/Q u_async_fifo_fifomem__397_/CLK
+ u_async_fifo_fifomem__397_/D TAP_TAPCELL_ROW_21_291/VPWR VSUBS TAP_TAPCELL_ROW_21_291/VPWR
+ VSUBS sky130_fd_sc_hd__dfxtp_1
Xu_async_fifo_fifomem__251_ VSUBS TAP_TAPCELL_ROW_51_501/VPWR TAP_TAPCELL_ROW_51_501/VPWR
+ VSUBS u_async_fifo_fifomem__251_/X u_async_fifo_fifomem__251_/A1 u_async_fifo_fifomem__251_/S
+ u_async_fifo_fifomem__251_/A0 sky130_fd_sc_hd__mux2_1
Xu_async_fifo_fifomem__320_ u_async_fifo_fifomem__320_/VGND TAP_TAPCELL_ROW_49_487/VPWR
+ TAP_TAPCELL_ROW_49_487/VPWR VSUBS u_async_fifo_fifomem__320_/X u_async_fifo_fifomem__320_/A1
+ u_async_fifo_fifomem__320_/S u_async_fifo_fifomem__320_/A0 sky130_fd_sc_hd__mux2_1
X_19_ _30_/VPB VSUBS VSUBS _30_/VPB _19_/A _19_/Y sky130_fd_sc_hd__clkinv_1
Xu_async_fifo_fifomem__449_ u_async_fifo_fifomem__449_/Q u_async_fifo_fifomem__449_/CLK
+ u_async_fifo_fifomem__449_/D u_async_fifo_fifomem__449_/VPB VSUBS u_async_fifo_fifomem__449_/VPWR
+ u_async_fifo_fifomem__449_/VGND sky130_fd_sc_hd__dfxtp_1
XPHY_EDGE_ROW_9_Left_76 PHY_EDGE_ROW_9_Left_76/VPWR PHY_EDGE_ROW_9_Left_76/VGND PHY_EDGE_ROW_9_Left_76/VPB
+ VSUBS sky130_fd_sc_hd__decap_3
Xu_axi_slave__150_ VSUBS u_axi_slave__240_/VPB u_axi_slave__150_/X u_axi_slave__150_/B
+ u_axi_slave__150_/A u_axi_slave__150_/C u_axi_slave__240_/VPB VSUBS sky130_fd_sc_hd__and3_1
Xu_async_fifo_fifomem__234_ VSUBS clkbuf_4_4_0_s_axi_aclk/VPB clkbuf_4_4_0_s_axi_aclk/VPB
+ VSUBS u_async_fifo_fifomem__234_/X u_async_fifo_fifomem__234_/A1 u_async_fifo_fifomem__234_/S
+ u_async_fifo_fifomem__234_/A0 sky130_fd_sc_hd__mux2_1
Xu_async_fifo_fifomem__303_ VSUBS u_async_fifo_fifomem__348_/VPWR u_async_fifo_fifomem__348_/VPB
+ VSUBS u_async_fifo_fifomem__303_/X u_async_fifo_fifomem__303_/A1 u_async_fifo_fifomem__303_/S
+ u_async_fifo_fifomem__303_/A0 sky130_fd_sc_hd__mux2_1
XPHY_EDGE_ROW_59_Left_126 PHY_EDGE_ROW_59_Left_126/VPWR PHY_EDGE_ROW_60_Left_127/VGND
+ PHY_EDGE_ROW_59_Left_126/VPB VSUBS sky130_fd_sc_hd__decap_3
Xu_axi_slave__202_ VSUBS u_axi_slave__240_/VPB u_axi_slave__240_/VPB VSUBS u_axi_slave__202_/CLK
+ u_axi_slave__202_/D u_axi_slave__202_/RESET_B u_axi_slave__202_/Q sky130_fd_sc_hd__dfrtp_1
Xu_async_fifo_fifomem__217_ VSUBS TAP_TAPCELL_ROW_33_374/VPWR VSUBS TAP_TAPCELL_ROW_33_374/VPWR
+ u_async_fifo_fifomem__217_/S0 u_async_fifo_fifomem__217_/A2 u_async_fifo_fifomem__217_/A3
+ u_async_fifo_fifomem__217_/S1 u_async_fifo_fifomem__217_/A1 u_async_fifo_fifomem__217_/A0
+ u_async_fifo_fifomem__217_/X sky130_fd_sc_hd__mux4_2
Xu_axi_slave__133_ VSUBS u_axi_slave__230_/VPB u_axi_slave__230_/VPB VSUBS u_axi_slave__133_/A3
+ u_axi_slave__133_/A2 u_axi_slave__133_/A1 u_axi_slave__133_/Y u_axi_slave__133_/B1
+ sky130_fd_sc_hd__a31oi_1
Xu_async_fifo_sync_r2w__3_ VSUBS clkbuf_0_uart_clk/VPB clkbuf_0_uart_clk/VPB VSUBS
+ u_async_fifo_sync_r2w__3_/CLK u_async_fifo_sync_r2w__3_/D u_async_fifo_sync_r2w__8_/RESET_B
+ u_async_fifo_sync_r2w__3_/Q sky130_fd_sc_hd__dfrtp_1
Xu_axi_slave__116_ u_axi_slave__116_/VPB VSUBS u_axi_slave__116_/VGND u_axi_slave__116_/VPWR
+ u_axi_slave__116_/A u_axi_slave__116_/B u_axi_slave__116_/Y sky130_fd_sc_hd__nor2_1
XPHY_EDGE_ROW_22_Left_89 PHY_EDGE_ROW_23_Left_90/VPWR PHY_EDGE_ROW_22_Left_89/VGND
+ PHY_EDGE_ROW_23_Left_90/VPB VSUBS sky130_fd_sc_hd__decap_3
Xu_uart_tx__102_ u_uart_tx__167_/VPB VSUBS VSUBS u_uart_tx__167_/VPB u_uart_tx__102_/A1
+ u_uart_tx__102_/A2 u_uart_tx__102_/B1 u_uart_tx__102_/X sky130_fd_sc_hd__o21a_1
Xu_async_fifo_fifomem__482_ u_async_fifo_fifomem__482_/Q u_async_fifo_fifomem__482_/CLK
+ u_async_fifo_fifomem__482_/D TAP_TAPCELL_ROW_31_359/VPWR VSUBS TAP_TAPCELL_ROW_31_359/VPWR
+ VSUBS sky130_fd_sc_hd__dfxtp_1
X_35_ VSUBS _35_/VPB _35_/VPB VSUBS _35_/CLK _35_/D _35_/RESET_B _35_/Q sky130_fd_sc_hd__dfrtp_1
Xu_async_fifo_wptr_full__22_ TAP_TAPCELL_ROW_17_265/VPWR VSUBS TAP_TAPCELL_ROW_17_265/VPWR
+ VSUBS u_async_fifo_wptr_full__22_/A2 u_async_fifo_wptr_full__22_/A1 u_async_fifo_wptr_full__22_/B1
+ u_async_fifo_wptr_full__22_/Y sky130_fd_sc_hd__a21oi_1
Xu_async_fifo_fifomem__396_ u_async_fifo_fifomem__396_/Q u_async_fifo_fifomem__396_/CLK
+ u_async_fifo_fifomem__396_/D TAP_TAPCELL_ROW_51_501/VPWR VSUBS TAP_TAPCELL_ROW_51_501/VPWR
+ VSUBS sky130_fd_sc_hd__dfxtp_1
Xu_async_fifo_fifomem__465_ u_async_fifo_fifomem__465_/Q u_async_fifo_fifomem__465_/CLK
+ u_async_fifo_fifomem__465_/D TAP_TAPCELL_ROW_44_450/VPWR VSUBS TAP_TAPCELL_ROW_44_450/VPWR
+ VSUBS sky130_fd_sc_hd__dfxtp_1
XPHY_EDGE_ROW_40_Left_107 PHY_EDGE_ROW_41_Left_108/VPWR PHY_EDGE_ROW_40_Left_107/VGND
+ PHY_EDGE_ROW_41_Left_108/VPB VSUBS sky130_fd_sc_hd__decap_3
Xu_async_fifo_fifomem__250_ VSUBS TAP_TAPCELL_ROW_35_389/VPWR TAP_TAPCELL_ROW_35_389/VPWR
+ VSUBS u_async_fifo_fifomem__250_/X u_async_fifo_fifomem__250_/A1 u_async_fifo_fifomem__250_/S
+ u_async_fifo_fifomem__250_/A0 sky130_fd_sc_hd__mux2_1
XPHY_EDGE_ROW_25_Left_92 PHY_EDGE_ROW_25_Left_92/VPWR PHY_EDGE_ROW_26_Left_93/VGND
+ PHY_EDGE_ROW_25_Left_92/VPB VSUBS sky130_fd_sc_hd__decap_3
X_18_ _28_/VPB VSUBS VSUBS _28_/VPB _18_/Y _18_/B _18_/C _18_/A_N sky130_fd_sc_hd__nand3b_1
Xu_async_fifo_fifomem__379_ u_async_fifo_fifomem__379_/Q u_async_fifo_fifomem__379_/CLK
+ u_async_fifo_fifomem__379_/D TAP_TAPCELL_ROW_38_409/VPWR VSUBS TAP_TAPCELL_ROW_38_409/VPWR
+ u_async_fifo_fifomem__379_/VGND sky130_fd_sc_hd__dfxtp_1
Xu_async_fifo_fifomem__448_ u_async_fifo_fifomem__448_/Q u_async_fifo_fifomem__448_/CLK
+ u_async_fifo_fifomem__448_/D TAP_TAPCELL_ROW_35_387/VPWR VSUBS TAP_TAPCELL_ROW_35_387/VPWR
+ VSUBS sky130_fd_sc_hd__dfxtp_1
Xu_async_fifo_fifomem__302_ u_async_fifo_fifomem__478_/VGND TAP_TAPCELL_ROW_51_500/VPWR
+ TAP_TAPCELL_ROW_51_500/VPWR VSUBS u_async_fifo_fifomem__302_/X u_async_fifo_fifomem__302_/A1
+ u_async_fifo_fifomem__302_/S u_async_fifo_fifomem__302_/A0 sky130_fd_sc_hd__mux2_1
Xu_async_fifo_fifomem__233_ VSUBS TAP_TAPCELL_ROW_33_374/VPWR TAP_TAPCELL_ROW_33_374/VPWR
+ VSUBS u_async_fifo_fifomem__233_/X u_async_fifo_fifomem__233_/A1 u_async_fifo_fifomem__233_/S
+ u_async_fifo_fifomem__233_/A0 sky130_fd_sc_hd__mux2_1
XPHY_EDGE_ROW_26_Right_26 PHY_EDGE_ROW_27_Right_27/VPWR PHY_EDGE_ROW_26_Right_26/VGND
+ PHY_EDGE_ROW_27_Right_27/VPB VSUBS sky130_fd_sc_hd__decap_3
XPHY_EDGE_ROW_17_Right_17 TAP_TAPCELL_ROW_17_266/VPWR PHY_EDGE_ROW_18_Right_18/VGND
+ TAP_TAPCELL_ROW_17_266/VPWR VSUBS sky130_fd_sc_hd__decap_3
XPHY_EDGE_ROW_53_Right_53 PHY_EDGE_ROW_53_Right_53/VPWR PHY_EDGE_ROW_54_Right_54/VGND
+ PHY_EDGE_ROW_53_Right_53/VPB VSUBS sky130_fd_sc_hd__decap_3
XPHY_EDGE_ROW_44_Right_44 PHY_EDGE_ROW_45_Right_45/VPWR PHY_EDGE_ROW_44_Right_44/VGND
+ PHY_EDGE_ROW_45_Right_45/VPB VSUBS sky130_fd_sc_hd__decap_3
XPHY_EDGE_ROW_35_Right_35 u_axi_slave__244_/VPB PHY_EDGE_ROW_36_Right_36/VGND u_axi_slave__244_/VPB
+ VSUBS sky130_fd_sc_hd__decap_3
XPHY_EDGE_ROW_62_Right_62 PHY_EDGE_ROW_63_Right_63/VPWR PHY_EDGE_ROW_62_Right_62/VGND
+ PHY_EDGE_ROW_63_Right_63/VPB VSUBS sky130_fd_sc_hd__decap_3
Xu_axi_slave__201_ VSUBS u_axi_slave__230_/VPB u_axi_slave__230_/VPB VSUBS u_axi_slave__201_/CLK
+ u_axi_slave__201_/D u_axi_slave__201_/RESET_B u_axi_slave__201_/Q sky130_fd_sc_hd__dfrtp_1
Xu_async_fifo_fifomem__216_ VSUBS clkbuf_0_s_axi_aclk/VPB VSUBS clkbuf_0_s_axi_aclk/VPB
+ u_async_fifo_fifomem__216_/S0 u_async_fifo_fifomem__216_/A2 u_async_fifo_fifomem__216_/A3
+ u_async_fifo_fifomem__216_/S1 u_async_fifo_fifomem__216_/A1 u_async_fifo_fifomem__216_/A0
+ u_async_fifo_fifomem__216_/X sky130_fd_sc_hd__mux4_2
Xu_axi_slave__132_ VSUBS u_axi_slave__220_/VPB u_axi_slave__220_/VPB VSUBS u_axi_slave__132_/Y
+ u_axi_slave__132_/B1 u_axi_slave__132_/C1 u_axi_slave__132_/A1 u_axi_slave__132_/A2
+ u_axi_slave__132_/B2 sky130_fd_sc_hd__a221oi_1
Xu_async_fifo_sync_r2w__2_ VSUBS TAP_TAPCELL_ROW_17_265/VPWR TAP_TAPCELL_ROW_17_265/VPWR
+ VSUBS u_async_fifo_sync_r2w__2_/CLK u_async_fifo_sync_r2w__2_/D u_async_fifo_sync_r2w__2_/RESET_B
+ u_async_fifo_sync_r2w__2_/Q sky130_fd_sc_hd__dfrtp_1
Xu_axi_slave__115_ u_axi_slave__184_/VPB VSUBS VSUBS u_axi_slave__184_/VPWR u_axi_slave__115_/A
+ u_axi_slave__115_/B u_axi_slave__115_/Y u_axi_slave__115_/C sky130_fd_sc_hd__nand3_1
Xclkbuf_4_2_0_s_axi_aclk clkbuf_4_2_0_s_axi_aclk/X clkbuf_4_2_0_s_axi_aclk/A clkbuf_4_2_0_s_axi_aclk/VPB
+ VSUBS VSUBS clkbuf_4_2_0_s_axi_aclk/VPB sky130_fd_sc_hd__clkbuf_8
Xu_uart_tx__101_ u_uart_tx__168_/VPB VSUBS VSUBS u_uart_tx__168_/VPB u_uart_tx__101_/Y
+ u_uart_tx__101_/D u_uart_tx__101_/C u_uart_tx__101_/B u_uart_tx__101_/A sky130_fd_sc_hd__nor4_1
Xu_async_fifo_fifomem__481_ u_async_fifo_fifomem__481_/Q u_async_fifo_fifomem__481_/CLK
+ u_async_fifo_fifomem__481_/D TAP_TAPCELL_ROW_41_431/VPWR VSUBS TAP_TAPCELL_ROW_41_431/VPWR
+ VSUBS sky130_fd_sc_hd__dfxtp_1
X_34_ VSUBS _38_/VPB _38_/VPB VSUBS _34_/CLK _34_/D _34_/RESET_B _34_/Q sky130_fd_sc_hd__dfrtp_1
Xu_async_fifo_wptr_full__21_ VSUBS TAP_TAPCELL_ROW_16_259/VPWR u_async_fifo_wptr_full__21_/B
+ u_async_fifo_wptr_full__21_/Y u_async_fifo_wptr_full__21_/A TAP_TAPCELL_ROW_16_259/VPWR
+ VSUBS sky130_fd_sc_hd__xnor2_1
Xu_async_fifo_fifomem__464_ u_async_fifo_fifomem__464_/Q u_async_fifo_fifomem__464_/CLK
+ u_async_fifo_fifomem__464_/D TAP_TAPCELL_ROW_33_374/VPWR VSUBS TAP_TAPCELL_ROW_33_374/VPWR
+ VSUBS sky130_fd_sc_hd__dfxtp_1
Xu_async_fifo_fifomem__395_ u_async_fifo_fifomem__395_/Q u_async_fifo_fifomem__395_/CLK
+ u_async_fifo_fifomem__395_/D TAP_TAPCELL_ROW_35_389/VPWR VSUBS TAP_TAPCELL_ROW_35_389/VPWR
+ VSUBS sky130_fd_sc_hd__dfxtp_1
X_17_ _29_/VPB VSUBS _29_/VPB VSUBS _17_/A2 _17_/A1 _17_/B1 _17_/X sky130_fd_sc_hd__a21o_1
Xu_async_fifo_fifomem__378_ u_async_fifo_fifomem__378_/Q u_async_fifo_fifomem__378_/CLK
+ u_async_fifo_fifomem__378_/D TAP_TAPCELL_ROW_31_359/VPWR VSUBS TAP_TAPCELL_ROW_31_359/VPWR
+ VSUBS sky130_fd_sc_hd__dfxtp_1
Xu_async_fifo_fifomem__447_ u_async_fifo_fifomem__447_/Q u_async_fifo_fifomem__447_/CLK
+ u_async_fifo_fifomem__447_/D u_async_fifo_fifomem__447_/VPB VSUBS u_async_fifo_fifomem__447_/VPWR
+ VSUBS sky130_fd_sc_hd__dfxtp_1
Xclkbuf_4_7_0_s_axi_aclk clkbuf_4_7_0_s_axi_aclk/X clkbuf_4_7_0_s_axi_aclk/A clkbuf_4_7_0_s_axi_aclk/VPB
+ VSUBS VSUBS clkbuf_4_7_0_s_axi_aclk/VPB sky130_fd_sc_hd__clkbuf_8
Xu_async_fifo_fifomem__232_ VSUBS TAP_TAPCELL_ROW_23_303/VPWR TAP_TAPCELL_ROW_23_303/VPWR
+ VSUBS u_async_fifo_fifomem__232_/X u_async_fifo_fifomem__232_/A1 u_async_fifo_fifomem__232_/S
+ u_async_fifo_fifomem__232_/A0 sky130_fd_sc_hd__mux2_1
Xu_async_fifo_fifomem__301_ VSUBS TAP_TAPCELL_ROW_20_284/VPWR TAP_TAPCELL_ROW_20_284/VPWR
+ VSUBS u_async_fifo_fifomem__301_/X u_async_fifo_fifomem__301_/A1 u_async_fifo_fifomem__301_/S
+ u_async_fifo_fifomem__301_/A0 sky130_fd_sc_hd__mux2_1
Xu_axi_slave__200_ VSUBS u_axi_slave__242_/VPB u_axi_slave__242_/VPB VSUBS u_axi_slave__200_/CLK
+ u_axi_slave__200_/D u_axi_slave__235_/RESET_B u_axi_slave__200_/Q sky130_fd_sc_hd__dfrtp_1
Xu_async_fifo_fifomem__215_ VSUBS TAP_TAPCELL_ROW_34_380/VPWR VSUBS TAP_TAPCELL_ROW_34_380/VPWR
+ u_async_fifo_fifomem__215_/S0 u_async_fifo_fifomem__215_/A2 u_async_fifo_fifomem__215_/A3
+ u_async_fifo_fifomem__215_/S1 u_async_fifo_fifomem__215_/A1 u_async_fifo_fifomem__215_/A0
+ u_async_fifo_fifomem__215_/X sky130_fd_sc_hd__mux4_2
Xu_axi_slave__131_ ANTENNA_2/VPB VSUBS VSUBS ANTENNA_2/VPB u_axi_slave__131_/A u_axi_slave__131_/B
+ u_axi_slave__131_/Y sky130_fd_sc_hd__nor2_1
Xu_axi_slave__114_ u_axi_slave__209_/VPB VSUBS VSUBS u_axi_slave__209_/VPB u_axi_slave__114_/A
+ u_axi_slave__114_/Y u_axi_slave__114_/B sky130_fd_sc_hd__nand2_1
Xu_async_fifo_sync_r2w__1_ VSUBS clkbuf_3_6__f_uart_clk/VPB clkbuf_3_6__f_uart_clk/VPB
+ VSUBS u_async_fifo_sync_r2w__1_/CLK u_async_fifo_sync_r2w__1_/D u_async_fifo_sync_r2w__1_/RESET_B
+ u_async_fifo_sync_r2w__1_/Q sky130_fd_sc_hd__dfrtp_1
Xu_uart_tx__100_ u_uart_tx__168_/VPB VSUBS u_uart_tx__168_/VPB VSUBS u_uart_tx__100_/B
+ u_uart_tx__100_/D u_uart_tx__100_/C u_uart_tx__100_/A u_uart_tx__100_/X sky130_fd_sc_hd__or4_1
Xu_async_fifo_fifomem__480_ u_async_fifo_fifomem__480_/Q u_async_fifo_fifomem__480_/CLK
+ u_async_fifo_fifomem__480_/D TAP_TAPCELL_ROW_31_359/VPWR VSUBS TAP_TAPCELL_ROW_31_359/VPWR
+ VSUBS sky130_fd_sc_hd__dfxtp_1
X_33_ VSUBS _38_/VPB _38_/VPB VSUBS _33_/CLK _33_/D _33_/RESET_B _33_/Q sky130_fd_sc_hd__dfrtp_1
Xu_async_fifo_wptr_full__20_ TAP_TAPCELL_ROW_17_265/VPWR VSUBS VSUBS TAP_TAPCELL_ROW_17_265/VPWR
+ u_async_fifo_wptr_full__20_/A u_async_fifo_wptr_full__20_/B u_async_fifo_wptr_full__20_/Y
+ sky130_fd_sc_hd__nor2_1
Xu_async_fifo_fifomem__394_ u_async_fifo_fifomem__394_/Q u_async_fifo_fifomem__394_/CLK
+ u_async_fifo_fifomem__394_/D clkbuf_4_3_0_s_axi_aclk/VPB VSUBS clkbuf_4_3_0_s_axi_aclk/VPB
+ VSUBS sky130_fd_sc_hd__dfxtp_1
Xu_async_fifo_fifomem__463_ u_async_fifo_fifomem__463_/Q u_async_fifo_fifomem__463_/CLK
+ u_async_fifo_fifomem__463_/D TAP_TAPCELL_ROW_20_282/VPWR VSUBS TAP_TAPCELL_ROW_20_282/VPWR
+ VSUBS sky130_fd_sc_hd__dfxtp_1
X_16_ _28_/VPB VSUBS _28_/VPB VSUBS _16_/B1 _16_/A1 _16_/A2 _16_/X _16_/B2 sky130_fd_sc_hd__a22o_1
Xu_async_fifo_fifomem__446_ u_async_fifo_fifomem__446_/Q u_async_fifo_fifomem__446_/CLK
+ u_async_fifo_fifomem__446_/D u_async_fifo_fifomem__446_/VPB VSUBS u_async_fifo_fifomem__446_/VPWR
+ u_async_fifo_fifomem__446_/VGND sky130_fd_sc_hd__dfxtp_1
Xu_async_fifo_fifomem__377_ u_async_fifo_fifomem__505_/VGND u_async_fifo_fifomem__377_/VPWR
+ u_async_fifo_fifomem__377_/VPB VSUBS u_async_fifo_fifomem__377_/X u_async_fifo_fifomem__377_/A1
+ u_async_fifo_fifomem__377_/S u_async_fifo_fifomem__377_/A0 sky130_fd_sc_hd__mux2_1
Xu_async_fifo_fifomem__300_ VSUBS TAP_TAPCELL_ROW_51_501/VPWR TAP_TAPCELL_ROW_51_501/VPWR
+ VSUBS u_async_fifo_fifomem__300_/X u_async_fifo_fifomem__300_/A1 u_async_fifo_fifomem__300_/S
+ u_async_fifo_fifomem__300_/A0 sky130_fd_sc_hd__mux2_1
Xu_async_fifo_fifomem__231_ VSUBS TAP_TAPCELL_ROW_47_471/VPWR TAP_TAPCELL_ROW_47_471/VPWR
+ VSUBS u_async_fifo_fifomem__231_/X u_async_fifo_fifomem__231_/A1 u_async_fifo_fifomem__231_/S
+ u_async_fifo_fifomem__231_/A0 sky130_fd_sc_hd__mux2_1
XPHY_EDGE_ROW_3_Right_3 PHY_EDGE_ROW_3_Right_3/VPWR PHY_EDGE_ROW_4_Right_4/VGND PHY_EDGE_ROW_3_Right_3/VPB
+ VSUBS sky130_fd_sc_hd__decap_3
Xu_async_fifo_fifomem__429_ u_async_fifo_fifomem__429_/Q u_async_fifo_fifomem__429_/CLK
+ u_async_fifo_fifomem__429_/D load_slew1/VPB VSUBS load_slew1/VPB VSUBS sky130_fd_sc_hd__dfxtp_1
XPHY_EDGE_ROW_37_Left_104 PHY_EDGE_ROW_37_Left_104/VPWR PHY_EDGE_ROW_38_Left_105/VGND
+ PHY_EDGE_ROW_37_Left_104/VPB VSUBS sky130_fd_sc_hd__decap_3
XPHY_EDGE_ROW_55_Left_122 PHY_EDGE_ROW_55_Left_122/VPWR PHY_EDGE_ROW_56_Left_123/VGND
+ PHY_EDGE_ROW_55_Left_122/VPB VSUBS sky130_fd_sc_hd__decap_3
XPHY_EDGE_ROW_46_Left_113 PHY_EDGE_ROW_47_Left_114/VPWR PHY_EDGE_ROW_46_Left_113/VGND
+ PHY_EDGE_ROW_47_Left_114/VPB VSUBS sky130_fd_sc_hd__decap_3
Xu_axi_slave__130_ u_axi_slave__228_/VPB VSUBS VSUBS u_axi_slave__228_/VPB u_axi_slave__130_/A
+ u_axi_slave__130_/B u_axi_slave__130_/Y u_axi_slave__130_/C sky130_fd_sc_hd__nand3_1
Xu_async_fifo_fifomem__214_ VSUBS TAP_TAPCELL_ROW_21_290/VPWR VSUBS TAP_TAPCELL_ROW_21_290/VPWR
+ u_async_fifo_fifomem__214_/S0 u_async_fifo_fifomem__214_/A2 u_async_fifo_fifomem__214_/A3
+ u_async_fifo_fifomem__214_/S1 u_async_fifo_fifomem__214_/A1 u_async_fifo_fifomem__214_/A0
+ u_async_fifo_fifomem__214_/X sky130_fd_sc_hd__mux4_2
XPHY_EDGE_ROW_64_Left_131 PHY_EDGE_ROW_65_Left_132/VPWR PHY_EDGE_ROW_64_Left_131/VGND
+ PHY_EDGE_ROW_65_Left_132/VPB VSUBS sky130_fd_sc_hd__decap_3
Xu_async_fifo_sync_r2w__0_ VSUBS TAP_TAPCELL_ROW_19_279/VPWR TAP_TAPCELL_ROW_19_279/VPWR
+ VSUBS u_async_fifo_sync_r2w__0_/CLK u_async_fifo_sync_r2w__0_/D u_async_fifo_sync_r2w__5_/RESET_B
+ u_async_fifo_sync_r2w__0_/Q sky130_fd_sc_hd__dfrtp_1
Xu_axi_slave__113_ VSUBS u_axi_slave__197_/VPB VSUBS u_axi_slave__197_/VPB u_axi_slave__113_/B1
+ u_axi_slave__113_/A1 u_axi_slave__113_/Y u_axi_slave__113_/A2 sky130_fd_sc_hd__o21ai_0
Xu_uart_tx__159_ VSUBS u_uart_tx__168_/VPB u_uart_tx__168_/VPB VSUBS u_uart_tx__159_/CLK
+ u_uart_tx__159_/D u_uart_tx__168_/RESET_B u_uart_tx__159_/Q sky130_fd_sc_hd__dfrtp_1
X_32_ VSUBS _35_/VPB _35_/VPB VSUBS _32_/CLK _32_/D _32_/RESET_B _32_/Q sky130_fd_sc_hd__dfrtp_1
Xu_async_fifo_fifomem__462_ u_async_fifo_fifomem__462_/Q u_async_fifo_fifomem__462_/CLK
+ u_async_fifo_fifomem__462_/D TAP_TAPCELL_ROW_49_485/VPWR VSUBS TAP_TAPCELL_ROW_49_485/VPWR
+ VSUBS sky130_fd_sc_hd__dfxtp_1
Xu_async_fifo_fifomem__393_ u_async_fifo_fifomem__393_/Q u_async_fifo_fifomem__393_/CLK
+ u_async_fifo_fifomem__393_/D TAP_TAPCELL_ROW_38_408/VPWR VSUBS TAP_TAPCELL_ROW_38_408/VPWR
+ VSUBS sky130_fd_sc_hd__dfxtp_1
X_15_ _28_/VPB VSUBS VSUBS _28_/VPB _15_/A_N _15_/B _15_/Y sky130_fd_sc_hd__nand2b_1
Xu_async_fifo_fifomem__376_ VSUBS clkbuf_0_s_axi_aclk/VPB clkbuf_0_s_axi_aclk/VPB
+ VSUBS u_async_fifo_fifomem__376_/X u_async_fifo_fifomem__376_/A1 u_async_fifo_fifomem__376_/S
+ u_async_fifo_fifomem__376_/A0 sky130_fd_sc_hd__mux2_1
Xu_async_fifo_fifomem__445_ u_async_fifo_fifomem__445_/Q u_async_fifo_fifomem__445_/CLK
+ u_async_fifo_fifomem__445_/D TAP_TAPCELL_ROW_24_311/VPWR VSUBS TAP_TAPCELL_ROW_24_311/VPWR
+ VSUBS sky130_fd_sc_hd__dfxtp_1
XPHY_EDGE_ROW_29_Left_96 PHY_EDGE_ROW_29_Left_96/VPWR PHY_EDGE_ROW_30_Left_97/VGND
+ PHY_EDGE_ROW_29_Left_96/VPB VSUBS sky130_fd_sc_hd__decap_3
Xu_async_fifo_fifomem__230_ VSUBS TAP_TAPCELL_ROW_22_297/VPWR TAP_TAPCELL_ROW_22_297/VPWR
+ VSUBS u_async_fifo_fifomem__230_/X u_async_fifo_fifomem__230_/A1 u_async_fifo_fifomem__230_/S
+ u_async_fifo_fifomem__230_/A0 sky130_fd_sc_hd__mux2_1
Xu_async_fifo_fifomem__428_ u_async_fifo_fifomem__428_/Q u_async_fifo_fifomem__428_/CLK
+ u_async_fifo_fifomem__428_/D u_async_fifo_fifomem__428_/VPB VSUBS u_async_fifo_fifomem__428_/VPWR
+ VSUBS sky130_fd_sc_hd__dfxtp_1
Xu_async_fifo_fifomem__359_ VSUBS TAP_TAPCELL_ROW_39_415/VPWR TAP_TAPCELL_ROW_39_415/VPWR
+ VSUBS u_async_fifo_fifomem__359_/X u_async_fifo_fifomem__359_/A1 u_async_fifo_fifomem__359_/S
+ u_async_fifo_fifomem__359_/A0 sky130_fd_sc_hd__mux2_1
XPHY_EDGE_ROW_22_Right_22 PHY_EDGE_ROW_23_Right_23/VPWR PHY_EDGE_ROW_22_Right_22/VGND
+ PHY_EDGE_ROW_23_Right_23/VPB VSUBS sky130_fd_sc_hd__decap_3
XPHY_EDGE_ROW_13_Right_13 TAP_TAPCELL_ROW_13_238/VPWR PHY_EDGE_ROW_14_Right_14/VGND
+ TAP_TAPCELL_ROW_13_238/VPWR VSUBS sky130_fd_sc_hd__decap_3
XPHY_EDGE_ROW_40_Right_40 PHY_EDGE_ROW_41_Right_41/VPWR PHY_EDGE_ROW_40_Right_40/VGND
+ PHY_EDGE_ROW_41_Right_41/VPB VSUBS sky130_fd_sc_hd__decap_3
XPHY_EDGE_ROW_31_Right_31 PHY_EDGE_ROW_31_Right_31/VPWR PHY_EDGE_ROW_32_Right_32/VGND
+ PHY_EDGE_ROW_31_Right_31/VPB VSUBS sky130_fd_sc_hd__decap_3
Xu_async_fifo_fifomem__213_ VSUBS TAP_TAPCELL_ROW_22_299/VPWR VSUBS TAP_TAPCELL_ROW_22_299/VPWR
+ u_async_fifo_fifomem__213_/S0 u_async_fifo_fifomem__213_/A2 u_async_fifo_fifomem__213_/A3
+ u_async_fifo_fifomem__213_/S1 u_async_fifo_fifomem__213_/A1 u_async_fifo_fifomem__213_/A0
+ u_async_fifo_fifomem__213_/X sky130_fd_sc_hd__mux4_2
Xu_axi_slave__189_ VSUBS ANTENNA_2/VPB ANTENNA_2/VPB VSUBS u_axi_slave__189_/X u_axi_slave__189_/A1
+ u_axi_slave__189_/S u_axi_slave__189_/A0 sky130_fd_sc_hd__mux2_1
XPHY_EDGE_ROW_16_Left_83 PHY_EDGE_ROW_17_Left_84/VPWR PHY_EDGE_ROW_16_Left_83/VGND
+ PHY_EDGE_ROW_17_Left_84/VPB VSUBS sky130_fd_sc_hd__decap_3
Xu_axi_slave__112_ VSUBS u_axi_slave__112_/VPB VSUBS u_axi_slave__112_/VPWR u_axi_slave__112_/B1
+ u_axi_slave__112_/A1 u_axi_slave__112_/Y u_axi_slave__112_/A2 sky130_fd_sc_hd__o21ai_0
Xu_uart_tx__158_ VSUBS u_uart_tx__168_/VPB u_uart_tx__168_/VPB VSUBS u_uart_tx__158_/CLK
+ u_uart_tx__158_/D u_uart_tx__158_/RESET_B u_uart_tx__158_/Q sky130_fd_sc_hd__dfrtp_1
XPHY_EDGE_ROW_1_Left_68 PHY_EDGE_ROW_1_Left_68/VPWR PHY_EDGE_ROW_2_Left_69/VGND PHY_EDGE_ROW_1_Left_68/VPB
+ VSUBS sky130_fd_sc_hd__decap_3
Xu_uart_tx__089_ u_uart_tx__142_/VPB VSUBS VSUBS u_uart_tx__142_/VPB u_uart_tx__089_/A1
+ u_uart_tx__089_/Y u_uart_tx__089_/C1 u_uart_tx__089_/B1 u_uart_tx__089_/A2 sky130_fd_sc_hd__o211ai_1
X_31_ VSUBS _31_/VPB _31_/VPB VSUBS _31_/CLK _31_/D _31_/RESET_B _31_/Q sky130_fd_sc_hd__dfrtp_1
Xu_async_fifo_fifomem__392_ u_async_fifo_fifomem__392_/Q u_async_fifo_fifomem__392_/CLK
+ u_async_fifo_fifomem__392_/D TAP_TAPCELL_ROW_33_374/VPWR VSUBS TAP_TAPCELL_ROW_33_374/VPWR
+ VSUBS sky130_fd_sc_hd__dfxtp_1
Xu_async_fifo_fifomem__461_ u_async_fifo_fifomem__461_/Q u_async_fifo_fifomem__461_/CLK
+ u_async_fifo_fifomem__461_/D TAP_TAPCELL_ROW_23_303/VPWR VSUBS TAP_TAPCELL_ROW_23_303/VPWR
+ u_async_fifo_fifomem__461_/VGND sky130_fd_sc_hd__dfxtp_1
X_14_ _28_/VPB VSUBS VSUBS _28_/VPB _14_/A _14_/Y sky130_fd_sc_hd__clkinv_1
Xu_async_fifo_fifomem__444_ u_async_fifo_fifomem__444_/Q u_async_fifo_fifomem__444_/CLK
+ u_async_fifo_fifomem__444_/D TAP_TAPCELL_ROW_51_499/VPWR VSUBS TAP_TAPCELL_ROW_51_499/VPWR
+ u_async_fifo_fifomem__444_/VGND sky130_fd_sc_hd__dfxtp_1
Xu_async_fifo_fifomem__375_ VSUBS TAP_TAPCELL_ROW_22_299/VPWR TAP_TAPCELL_ROW_22_299/VPWR
+ VSUBS u_async_fifo_fifomem__375_/X u_async_fifo_fifomem__375_/A1 u_async_fifo_fifomem__375_/S
+ u_async_fifo_fifomem__375_/A0 sky130_fd_sc_hd__mux2_1
XPHY_EDGE_ROW_4_Left_71 PHY_EDGE_ROW_5_Left_72/VPWR PHY_EDGE_ROW_4_Left_71/VGND PHY_EDGE_ROW_5_Left_72/VPB
+ VSUBS sky130_fd_sc_hd__decap_3
Xu_async_fifo_fifomem__427_ u_async_fifo_fifomem__427_/Q u_async_fifo_fifomem__427_/CLK
+ u_async_fifo_fifomem__427_/D TAP_TAPCELL_ROW_34_383/VPWR VSUBS TAP_TAPCELL_ROW_34_383/VPWR
+ VSUBS sky130_fd_sc_hd__dfxtp_1
Xu_async_fifo_fifomem__289_ VSUBS TAP_TAPCELL_ROW_37_403/VPWR TAP_TAPCELL_ROW_37_403/VPWR
+ VSUBS u_async_fifo_fifomem__289_/X u_async_fifo_fifomem__289_/A1 u_async_fifo_fifomem__289_/S
+ u_async_fifo_fifomem__289_/A0 sky130_fd_sc_hd__mux2_1
Xu_async_fifo_fifomem__358_ VSUBS TAP_TAPCELL_ROW_36_394/VPWR TAP_TAPCELL_ROW_36_394/VPWR
+ VSUBS u_async_fifo_fifomem__358_/X u_async_fifo_fifomem__358_/A1 u_async_fifo_fifomem__358_/S
+ u_async_fifo_fifomem__358_/A0 sky130_fd_sc_hd__mux2_1
XPHY_EDGE_ROW_30_Left_97 PHY_EDGE_ROW_31_Left_98/VPWR PHY_EDGE_ROW_30_Left_97/VGND
+ PHY_EDGE_ROW_31_Left_98/VPB VSUBS sky130_fd_sc_hd__decap_3
Xu_async_fifo_fifomem__212_ VSUBS TAP_TAPCELL_ROW_21_290/VPWR VSUBS TAP_TAPCELL_ROW_21_290/VPWR
+ u_async_fifo_fifomem__212_/S0 u_async_fifo_fifomem__212_/A2 u_async_fifo_fifomem__212_/A3
+ u_async_fifo_fifomem__212_/S1 u_async_fifo_fifomem__212_/A1 u_async_fifo_fifomem__212_/A0
+ u_async_fifo_fifomem__212_/X sky130_fd_sc_hd__mux4_2
Xu_axi_slave__188_ VSUBS u_axi_slave__237_/VPB u_axi_slave__237_/VPB VSUBS u_axi_slave__188_/X
+ u_axi_slave__188_/A1 u_axi_slave__188_/S u_axi_slave__188_/A0 sky130_fd_sc_hd__mux2_1
Xu_axi_slave__111_ u_axi_slave__112_/VPB VSUBS VSUBS u_axi_slave__112_/VPWR u_axi_slave__111_/A
+ u_axi_slave__111_/SLEEP u_axi_slave__111_/X sky130_fd_sc_hd__lpflow_isobufsrc_1
Xu_uart_tx__157_ VSUBS u_uart_tx__168_/VPB u_uart_tx__168_/VPB VSUBS u_uart_tx__157_/CLK
+ u_uart_tx__157_/D u_uart_tx__157_/RESET_B u_uart_tx__157_/Q sky130_fd_sc_hd__dfrtp_1
Xu_uart_tx__088_ u_uart_tx__142_/VPB u_uart_tx__091_/VGND u_uart_tx__142_/VPB VSUBS
+ u_uart_tx__088_/Y u_uart_tx__088_/C1 u_uart_tx__088_/B1 u_uart_tx__088_/A1 u_uart_tx__088_/A2
+ sky130_fd_sc_hd__a211oi_1
X_30_ VSUBS _30_/VPB _30_/VPB VSUBS _30_/CLK _30_/D _30_/RESET_B _30_/Q sky130_fd_sc_hd__dfrtp_1
Xu_async_fifo_fifomem__460_ u_async_fifo_fifomem__460_/Q u_async_fifo_fifomem__460_/CLK
+ u_async_fifo_fifomem__460_/D TAP_TAPCELL_ROW_51_499/VPWR VSUBS TAP_TAPCELL_ROW_51_499/VPWR
+ VSUBS sky130_fd_sc_hd__dfxtp_1
Xu_async_fifo_fifomem__391_ u_async_fifo_fifomem__391_/Q u_async_fifo_fifomem__391_/CLK
+ u_async_fifo_fifomem__391_/D TAP_TAPCELL_ROW_18_268/VPWR VSUBS TAP_TAPCELL_ROW_18_268/VPWR
+ VSUBS sky130_fd_sc_hd__dfxtp_1
Xu_async_fifo_fifomem__374_ VSUBS TAP_TAPCELL_ROW_45_459/VPWR TAP_TAPCELL_ROW_45_459/VPWR
+ VSUBS u_async_fifo_fifomem__374_/X u_async_fifo_fifomem__374_/A1 u_async_fifo_fifomem__374_/S
+ u_async_fifo_fifomem__374_/A0 sky130_fd_sc_hd__mux2_1
Xclkbuf_4_12_0_s_axi_aclk clkbuf_4_12_0_s_axi_aclk/X clkbuf_4_12_0_s_axi_aclk/A u_axi_slave__199_/VPB
+ VSUBS clkbuf_4_13_0_s_axi_aclk/VGND u_axi_slave__199_/VPB sky130_fd_sc_hd__clkbuf_8
Xu_async_fifo_fifomem__443_ u_async_fifo_fifomem__443_/Q u_async_fifo_fifomem__443_/CLK
+ u_async_fifo_fifomem__443_/D TAP_TAPCELL_ROW_35_387/VPWR VSUBS TAP_TAPCELL_ROW_35_387/VPWR
+ VSUBS sky130_fd_sc_hd__dfxtp_1
Xu_async_fifo_fifomem__426_ u_async_fifo_fifomem__426_/Q u_async_fifo_fifomem__426_/CLK
+ u_async_fifo_fifomem__426_/D clkbuf_0_s_axi_aclk/VPB VSUBS clkbuf_0_s_axi_aclk/VPB
+ VSUBS sky130_fd_sc_hd__dfxtp_1
Xu_async_fifo_fifomem__288_ VSUBS clkbuf_0_s_axi_aclk/VPB clkbuf_0_s_axi_aclk/VPB
+ VSUBS u_async_fifo_fifomem__288_/X u_async_fifo_fifomem__288_/A1 u_async_fifo_fifomem__288_/S
+ u_async_fifo_fifomem__288_/A0 sky130_fd_sc_hd__mux2_1
Xu_async_fifo_fifomem__357_ u_async_fifo_fifomem__357_/VGND TAP_TAPCELL_ROW_19_275/VPWR
+ TAP_TAPCELL_ROW_19_275/VPWR VSUBS u_async_fifo_fifomem__357_/X u_async_fifo_fifomem__357_/A1
+ u_async_fifo_fifomem__357_/S u_async_fifo_fifomem__357_/A0 sky130_fd_sc_hd__mux2_1
Xu_async_fifo_fifomem__211_ VSUBS TAP_TAPCELL_ROW_19_275/VPWR VSUBS TAP_TAPCELL_ROW_19_275/VPWR
+ u_async_fifo_fifomem__211_/S0 u_async_fifo_fifomem__211_/A2 u_async_fifo_fifomem__211_/A3
+ u_async_fifo_fifomem__211_/S1 u_async_fifo_fifomem__211_/A1 u_async_fifo_fifomem__211_/A0
+ u_async_fifo_fifomem__211_/X sky130_fd_sc_hd__mux4_2
XPHY_EDGE_ROW_7_Right_7 PHY_EDGE_ROW_7_Right_7/VPWR PHY_EDGE_ROW_8_Right_8/VGND PHY_EDGE_ROW_7_Right_7/VPB
+ VSUBS sky130_fd_sc_hd__decap_3
Xu_async_fifo_fifomem__409_ u_async_fifo_fifomem__409_/Q u_async_fifo_fifomem__409_/CLK
+ u_async_fifo_fifomem__409_/D TAP_TAPCELL_ROW_43_446/VPWR VSUBS TAP_TAPCELL_ROW_43_446/VPWR
+ VSUBS sky130_fd_sc_hd__dfxtp_1
XPHY_EDGE_ROW_33_Left_100 PHY_EDGE_ROW_32_Left_99/VPWR PHY_EDGE_ROW_34_Left_101/VGND
+ PHY_EDGE_ROW_32_Left_99/VPB VSUBS sky130_fd_sc_hd__decap_3
Xu_axi_slave__187_ VSUBS u_axi_slave__236_/VPB u_axi_slave__236_/VPB VSUBS u_axi_slave__187_/X
+ u_axi_slave__187_/A1 u_axi_slave__187_/S u_axi_slave__187_/A0 sky130_fd_sc_hd__mux2_1
Xu_axi_slave__110_ u_axi_slave__112_/VPB VSUBS VSUBS u_axi_slave__112_/VPWR u_axi_slave__110_/A
+ u_axi_slave__110_/SLEEP u_axi_slave__110_/X sky130_fd_sc_hd__lpflow_isobufsrc_1
Xu_axi_slave__239_ VSUBS ANTENNA_1/VPB ANTENNA_1/VPB VSUBS u_axi_slave__239_/CLK u_axi_slave__239_/D
+ u_axi_slave__239_/RESET_B u_axi_slave__239_/Q sky130_fd_sc_hd__dfrtp_1
Xu_uart_tx__156_ VSUBS u_uart_tx__163_/VPB u_uart_tx__163_/VPB VSUBS u_uart_tx__156_/CLK
+ u_uart_tx__156_/D u_uart_tx__156_/RESET_B u_uart_tx__156_/Q sky130_fd_sc_hd__dfrtp_1
Xu_uart_tx__087_ u_uart_tx__137_/VPB VSUBS u_uart_tx__091_/VGND u_uart_tx__137_/VPB
+ u_uart_tx__087_/A u_uart_tx__087_/B u_uart_tx__087_/Y sky130_fd_sc_hd__nor2_1
Xu_async_fifo_fifomem__390_ u_async_fifo_fifomem__390_/Q u_async_fifo_fifomem__390_/CLK
+ u_async_fifo_fifomem__390_/D clkbuf_4_5_0_s_axi_aclk/VPB VSUBS clkbuf_4_5_0_s_axi_aclk/VPB
+ VSUBS sky130_fd_sc_hd__dfxtp_1
Xu_uart_tx__139_ VSUBS _35_/VPB _35_/VPB VSUBS u_uart_tx__139_/CLK u_uart_tx__139_/D
+ _35_/RESET_B u_uart_tx__139_/Q sky130_fd_sc_hd__dfrtp_1
Xu_async_fifo_fifomem__373_ VSUBS u_axi_slave__232_/VPB u_axi_slave__232_/VPB VSUBS
+ u_async_fifo_fifomem__373_/X u_async_fifo_fifomem__373_/A1 u_async_fifo_fifomem__373_/S
+ u_async_fifo_fifomem__373_/A0 sky130_fd_sc_hd__mux2_1
Xu_async_fifo_fifomem__442_ u_async_fifo_fifomem__442_/Q u_async_fifo_fifomem__442_/CLK
+ u_async_fifo_fifomem__442_/D TAP_TAPCELL_ROW_27_331/VPWR VSUBS TAP_TAPCELL_ROW_27_331/VPWR
+ VSUBS sky130_fd_sc_hd__dfxtp_1
Xu_async_fifo_fifomem__356_ VSUBS TAP_TAPCELL_ROW_46_465/VPWR TAP_TAPCELL_ROW_46_465/VPWR
+ VSUBS u_async_fifo_fifomem__356_/X u_async_fifo_fifomem__356_/A1 u_async_fifo_fifomem__356_/S
+ u_async_fifo_fifomem__356_/A0 sky130_fd_sc_hd__mux2_1
Xu_async_fifo_fifomem__425_ u_async_fifo_fifomem__425_/Q u_async_fifo_fifomem__425_/CLK
+ u_async_fifo_fifomem__425_/D clkbuf_4_5_0_s_axi_aclk/VPB VSUBS clkbuf_4_5_0_s_axi_aclk/VPB
+ VSUBS sky130_fd_sc_hd__dfxtp_1
Xu_async_fifo_fifomem__287_ u_async_fifo_fifomem__315_/VPB VSUBS VSUBS u_async_fifo_fifomem__315_/VPWR
+ u_async_fifo_fifomem__287_/Y u_async_fifo_fifomem__287_/C u_async_fifo_fifomem__287_/B
+ u_async_fifo_fifomem__287_/D u_async_fifo_fifomem__287_/A_N sky130_fd_sc_hd__nand4b_1
Xu_async_fifo_sync_w2r__9_ VSUBS TAP_TAPCELL_ROW_15_251/VPWR TAP_TAPCELL_ROW_15_251/VPWR
+ VSUBS u_async_fifo_sync_w2r__9_/CLK u_async_fifo_sync_w2r__9_/D u_async_fifo_sync_w2r__9_/RESET_B
+ u_async_fifo_sync_w2r__9_/Q sky130_fd_sc_hd__dfrtp_1
Xu_async_fifo_fifomem__408_ u_async_fifo_fifomem__408_/Q u_async_fifo_fifomem__408_/CLK
+ u_async_fifo_fifomem__408_/D TAP_TAPCELL_ROW_32_369/VPWR VSUBS TAP_TAPCELL_ROW_32_369/VPWR
+ VSUBS sky130_fd_sc_hd__dfxtp_1
Xu_async_fifo_fifomem__210_ VSUBS TAP_TAPCELL_ROW_23_303/VPWR VSUBS TAP_TAPCELL_ROW_23_303/VPWR
+ u_async_fifo_fifomem__210_/S0 u_async_fifo_fifomem__210_/A2 u_async_fifo_fifomem__210_/A3
+ u_async_fifo_fifomem__210_/S1 u_async_fifo_fifomem__210_/A1 u_async_fifo_fifomem__210_/A0
+ u_async_fifo_fifomem__210_/X sky130_fd_sc_hd__mux4_2
Xu_axi_slave__186_ VSUBS u_axi_slave__227_/VPB u_axi_slave__227_/VPB VSUBS u_axi_slave__186_/X
+ u_axi_slave__186_/A1 u_axi_slave__186_/S u_axi_slave__186_/A0 sky130_fd_sc_hd__mux2_1
Xu_async_fifo_rptr_empty__47_ VSUBS TAP_TAPCELL_ROW_15_250/VPWR TAP_TAPCELL_ROW_15_250/VPWR
+ VSUBS u_async_fifo_rptr_empty__47_/CLK u_async_fifo_rptr_empty__47_/D u_async_fifo_rptr_empty__47_/RESET_B
+ u_async_fifo_rptr_empty__47_/Q sky130_fd_sc_hd__dfrtp_1
Xu_async_fifo_fifomem__339_ VSUBS TAP_TAPCELL_ROW_16_254/VPWR TAP_TAPCELL_ROW_16_254/VPWR
+ VSUBS u_async_fifo_fifomem__339_/X u_async_fifo_fifomem__339_/A1 u_async_fifo_fifomem__339_/S
+ u_async_fifo_fifomem__339_/A0 sky130_fd_sc_hd__mux2_1
Xu_axi_slave__238_ VSUBS ANTENNA_2/VPB ANTENNA_2/VPB VSUBS u_axi_slave__238_/CLK u_axi_slave__238_/D
+ u_axi_slave__238_/RESET_B u_axi_slave__238_/Q sky130_fd_sc_hd__dfrtp_1
Xu_axi_slave__169_ VSUBS u_axi_slave__211_/VPB u_axi_slave__211_/VPB VSUBS u_axi_slave__169_/X
+ u_axi_slave__169_/A1 u_axi_slave__169_/S u_axi_slave__169_/A0 sky130_fd_sc_hd__mux2_1
XPHY_EDGE_ROW_52_Left_119 PHY_EDGE_ROW_53_Left_120/VPWR PHY_EDGE_ROW_52_Left_119/VGND
+ PHY_EDGE_ROW_53_Left_120/VPB VSUBS sky130_fd_sc_hd__decap_3
Xu_uart_tx__155_ u_uart_tx__155_/VGND u_uart_tx__163_/VPB u_uart_tx__163_/VPB VSUBS
+ u_uart_tx__155_/CLK u_uart_tx__155_/D u_uart_tx__155_/RESET_B u_uart_tx__155_/Q
+ sky130_fd_sc_hd__dfrtp_1
Xu_uart_tx__086_ u_uart_tx__086_/VPB VSUBS VSUBS u_uart_tx__086_/VPB u_uart_tx__086_/C_N
+ u_uart_tx__086_/B u_uart_tx__086_/Y u_uart_tx__086_/A sky130_fd_sc_hd__nor3b_1
XPHY_EDGE_ROW_61_Left_128 PHY_EDGE_ROW_61_Left_128/VPWR PHY_EDGE_ROW_62_Left_129/VGND
+ PHY_EDGE_ROW_61_Left_128/VPB VSUBS sky130_fd_sc_hd__decap_3
XPHY_EDGE_ROW_29_Right_29 PHY_EDGE_ROW_29_Right_29/VPWR PHY_EDGE_ROW_30_Right_30/VGND
+ PHY_EDGE_ROW_29_Right_29/VPB VSUBS sky130_fd_sc_hd__decap_3
Xu_uart_tx__069_ u_uart_tx__166_/VPB VSUBS VSUBS u_uart_tx__166_/VPB u_uart_tx__069_/A
+ u_uart_tx__069_/Y sky130_fd_sc_hd__clkinv_1
Xu_uart_tx__138_ VSUBS _28_/VPB _28_/VPB VSUBS u_uart_tx__138_/CLK u_uart_tx__138_/D
+ u_uart_tx__138_/RESET_B u_uart_tx__138_/Q sky130_fd_sc_hd__dfrtp_1
XPHY_EDGE_ROW_56_Right_56 PHY_EDGE_ROW_57_Right_57/VPWR PHY_EDGE_ROW_56_Right_56/VGND
+ PHY_EDGE_ROW_57_Right_57/VPB VSUBS sky130_fd_sc_hd__decap_3
XPHY_EDGE_ROW_47_Right_47 u_axi_slave__242_/VPB PHY_EDGE_ROW_48_Right_48/VGND u_axi_slave__242_/VPB
+ VSUBS sky130_fd_sc_hd__decap_3
XPHY_EDGE_ROW_38_Right_38 PHY_EDGE_ROW_39_Right_39/VPWR PHY_EDGE_ROW_38_Right_38/VGND
+ PHY_EDGE_ROW_39_Right_39/VPB VSUBS sky130_fd_sc_hd__decap_3
XPHY_EDGE_ROW_65_Right_65 PHY_EDGE_ROW_65_Right_65/VPWR PHY_EDGE_ROW_66_Right_66/VGND
+ PHY_EDGE_ROW_65_Right_65/VPB VSUBS sky130_fd_sc_hd__decap_3
Xu_async_fifo_fifomem__372_ VSUBS TAP_TAPCELL_ROW_44_453/VPWR TAP_TAPCELL_ROW_44_453/VPWR
+ VSUBS u_async_fifo_fifomem__372_/X u_async_fifo_fifomem__372_/A1 u_async_fifo_fifomem__372_/S
+ u_async_fifo_fifomem__372_/A0 sky130_fd_sc_hd__mux2_1
Xu_async_fifo_fifomem__441_ u_async_fifo_fifomem__441_/Q u_async_fifo_fifomem__441_/CLK
+ u_async_fifo_fifomem__441_/D TAP_TAPCELL_ROW_41_431/VPWR VSUBS TAP_TAPCELL_ROW_41_431/VPWR
+ VSUBS sky130_fd_sc_hd__dfxtp_1
Xu_async_fifo_fifomem__424_ u_async_fifo_fifomem__424_/Q u_async_fifo_fifomem__424_/CLK
+ u_async_fifo_fifomem__424_/D TAP_TAPCELL_ROW_33_374/VPWR VSUBS TAP_TAPCELL_ROW_33_374/VPWR
+ VSUBS sky130_fd_sc_hd__dfxtp_1
Xu_async_fifo_fifomem__286_ TAP_TAPCELL_ROW_23_304/VPWR VSUBS VSUBS TAP_TAPCELL_ROW_23_304/VPWR
+ u_async_fifo_fifomem__286_/A_N u_async_fifo_fifomem__286_/B u_async_fifo_fifomem__286_/Y
+ sky130_fd_sc_hd__nand2b_1
Xu_async_fifo_fifomem__355_ VSUBS u_async_fifo_fifomem__389_/VPWR u_async_fifo_fifomem__389_/VPB
+ VSUBS u_async_fifo_fifomem__355_/X u_async_fifo_fifomem__355_/A1 u_async_fifo_fifomem__355_/S
+ u_async_fifo_fifomem__355_/A0 sky130_fd_sc_hd__mux2_1
XPHY_EDGE_ROW_8_Left_75 PHY_EDGE_ROW_9_Left_76/VPWR PHY_EDGE_ROW_8_Left_75/VGND PHY_EDGE_ROW_9_Left_76/VPB
+ VSUBS sky130_fd_sc_hd__decap_3
Xu_async_fifo_sync_w2r__8_ VSUBS clkbuf_0_uart_clk/VPB clkbuf_0_uart_clk/VPB VSUBS
+ u_async_fifo_sync_w2r__8_/CLK u_async_fifo_sync_w2r__8_/D u_async_fifo_sync_w2r__8_/RESET_B
+ u_async_fifo_sync_w2r__8_/Q sky130_fd_sc_hd__dfrtp_1
Xu_async_fifo_fifomem__338_ VSUBS clkbuf_4_5_0_s_axi_aclk/VPB clkbuf_4_5_0_s_axi_aclk/VPB
+ VSUBS u_async_fifo_fifomem__338_/X u_async_fifo_fifomem__338_/A1 u_async_fifo_fifomem__338_/S
+ u_async_fifo_fifomem__338_/A0 sky130_fd_sc_hd__mux2_1
Xu_async_fifo_fifomem__269_ VSUBS TAP_TAPCELL_ROW_39_416/VPWR TAP_TAPCELL_ROW_39_416/VPWR
+ VSUBS u_async_fifo_fifomem__269_/X u_async_fifo_fifomem__269_/A1 u_async_fifo_fifomem__269_/S
+ u_async_fifo_fifomem__269_/A0 sky130_fd_sc_hd__mux2_1
Xu_axi_slave__185_ VSUBS u_axi_slave__244_/VPB u_axi_slave__244_/VPB VSUBS u_axi_slave__185_/X
+ u_axi_slave__185_/A1 u_axi_slave__185_/S u_axi_slave__185_/A0 sky130_fd_sc_hd__mux2_1
Xu_async_fifo_fifomem__407_ u_async_fifo_fifomem__407_/Q u_async_fifo_fifomem__407_/CLK
+ u_async_fifo_fifomem__407_/D clkbuf_4_9_0_s_axi_aclk/VPB VSUBS clkbuf_4_9_0_s_axi_aclk/VPB
+ VSUBS sky130_fd_sc_hd__dfxtp_1
Xu_async_fifo_rptr_empty__46_ VSUBS TAP_TAPCELL_ROW_12_229/VPWR TAP_TAPCELL_ROW_12_229/VPWR
+ VSUBS u_async_fifo_rptr_empty__46_/CLK u_async_fifo_rptr_empty__46_/D u_async_fifo_rptr_empty__46_/RESET_B
+ u_async_fifo_rptr_empty__46_/Q sky130_fd_sc_hd__dfrtp_1
Xu_axi_slave__237_ VSUBS u_axi_slave__237_/VPB u_axi_slave__237_/VPB VSUBS u_axi_slave__237_/CLK
+ u_axi_slave__237_/D u_axi_slave__237_/RESET_B u_axi_slave__237_/Q sky130_fd_sc_hd__dfrtp_1
Xu_axi_slave__099_ u_axi_slave__237_/VPB VSUBS VSUBS u_axi_slave__237_/VPB u_axi_slave__099_/A
+ u_axi_slave__099_/B u_axi_slave__099_/Y sky130_fd_sc_hd__nor2_1
Xu_axi_slave__168_ VSUBS u_axi_slave__217_/VPB u_axi_slave__217_/VPB VSUBS u_axi_slave__168_/X
+ u_axi_slave__168_/A1 u_axi_slave__168_/S u_axi_slave__168_/A0 sky130_fd_sc_hd__mux2_1
Xu_uart_tx__085_ u_uart_tx__132_/VPB VSUBS VSUBS u_uart_tx__132_/VPWR u_uart_tx__085_/A
+ u_uart_tx__085_/Y u_uart_tx__085_/B sky130_fd_sc_hd__nand2_1
Xu_uart_tx__154_ VSUBS u_uart_tx__167_/VPB u_uart_tx__167_/VPB VSUBS u_uart_tx__154_/CLK
+ u_uart_tx__154_/D u_uart_tx__154_/RESET_B u_uart_tx__154_/Q sky130_fd_sc_hd__dfrtp_1
Xu_async_fifo_rptr_empty__29_ VSUBS _38_/VPB _38_/VPB VSUBS u_async_fifo_rptr_empty__29_/X
+ u_async_fifo_rptr_empty__29_/A1 u_async_fifo_rptr_empty__29_/S u_async_fifo_rptr_empty__29_/A0
+ sky130_fd_sc_hd__mux2_1
XPHY_EDGE_ROW_21_Left_88 PHY_EDGE_ROW_21_Left_88/VPWR PHY_EDGE_ROW_22_Left_89/VGND
+ PHY_EDGE_ROW_21_Left_88/VPB VSUBS sky130_fd_sc_hd__decap_3
Xclkbuf_4_3_0_s_axi_aclk clkbuf_4_3_0_s_axi_aclk/X clkbuf_4_3_0_s_axi_aclk/A clkbuf_4_3_0_s_axi_aclk/VPB
+ VSUBS VSUBS clkbuf_4_3_0_s_axi_aclk/VPB sky130_fd_sc_hd__clkbuf_8
Xu_uart_tx__068_ u_uart_tx__167_/VPB VSUBS VSUBS u_uart_tx__167_/VPB u_uart_tx__068_/A
+ u_uart_tx__068_/Y sky130_fd_sc_hd__clkinv_1
Xu_uart_tx__137_ VSUBS u_uart_tx__137_/VPB u_uart_tx__137_/VPB VSUBS u_uart_tx__137_/CLK
+ u_uart_tx__137_/D u_uart_tx__137_/RESET_B u_uart_tx__137_/Q sky130_fd_sc_hd__dfrtp_1
Xu_async_fifo_fifomem__371_ VSUBS u_async_fifo_fifomem__371_/VPWR u_async_fifo_fifomem__371_/VPB
+ VSUBS u_async_fifo_fifomem__371_/X u_async_fifo_fifomem__371_/A1 u_async_fifo_fifomem__371_/S
+ u_async_fifo_fifomem__371_/A0 sky130_fd_sc_hd__mux2_1
Xu_async_fifo_fifomem__440_ u_async_fifo_fifomem__440_/Q u_async_fifo_fifomem__440_/CLK
+ u_async_fifo_fifomem__440_/D TAP_TAPCELL_ROW_33_374/VPWR VSUBS TAP_TAPCELL_ROW_33_374/VPWR
+ VSUBS sky130_fd_sc_hd__dfxtp_1
Xu_async_fifo_fifomem__354_ VSUBS u_async_fifo_fifomem__484_/VPWR u_async_fifo_fifomem__484_/VPB
+ VSUBS u_async_fifo_fifomem__354_/X u_async_fifo_fifomem__354_/A1 u_async_fifo_fifomem__354_/S
+ u_async_fifo_fifomem__354_/A0 sky130_fd_sc_hd__mux2_1
Xu_async_fifo_fifomem__285_ VSUBS clkbuf_4_5_0_s_axi_aclk/VPB clkbuf_4_5_0_s_axi_aclk/VPB
+ VSUBS u_async_fifo_fifomem__285_/X u_async_fifo_fifomem__285_/A1 u_async_fifo_fifomem__285_/S
+ u_async_fifo_fifomem__285_/A0 sky130_fd_sc_hd__mux2_1
XPHY_EDGE_ROW_24_Left_91 PHY_EDGE_ROW_25_Left_92/VPWR PHY_EDGE_ROW_24_Left_91/VGND
+ PHY_EDGE_ROW_25_Left_92/VPB VSUBS sky130_fd_sc_hd__decap_3
Xu_async_fifo_fifomem__423_ u_async_fifo_fifomem__423_/Q u_async_fifo_fifomem__423_/CLK
+ u_async_fifo_fifomem__423_/D TAP_TAPCELL_ROW_23_303/VPWR VSUBS TAP_TAPCELL_ROW_23_303/VPWR
+ VSUBS sky130_fd_sc_hd__dfxtp_1
Xu_async_fifo_sync_w2r__7_ VSUBS TAP_TAPCELL_ROW_17_266/VPWR TAP_TAPCELL_ROW_17_266/VPWR
+ VSUBS u_async_fifo_sync_w2r__7_/CLK u_async_fifo_sync_w2r__7_/D u_async_fifo_sync_w2r__7_/RESET_B
+ u_async_fifo_sync_w2r__7_/Q sky130_fd_sc_hd__dfrtp_1
Xu_async_fifo_fifomem__406_ u_async_fifo_fifomem__406_/Q u_async_fifo_fifomem__406_/CLK
+ u_async_fifo_fifomem__406_/D TAP_TAPCELL_ROW_47_473/VPWR VSUBS TAP_TAPCELL_ROW_47_473/VPWR
+ VSUBS sky130_fd_sc_hd__dfxtp_1
Xu_async_fifo_fifomem__199_ VSUBS TAP_TAPCELL_ROW_47_473/VPWR u_async_fifo_fifomem__492_/VGND
+ TAP_TAPCELL_ROW_47_473/VPWR u_async_fifo_fifomem__199_/S0 u_async_fifo_fifomem__199_/A2
+ u_async_fifo_fifomem__199_/A3 u_async_fifo_fifomem__199_/S1 u_async_fifo_fifomem__199_/A1
+ u_async_fifo_fifomem__199_/A0 u_async_fifo_fifomem__199_/X sky130_fd_sc_hd__mux4_2
Xu_axi_slave__184_ VSUBS u_axi_slave__184_/VPWR u_axi_slave__184_/VPB VSUBS u_axi_slave__184_/X
+ u_axi_slave__184_/A1 u_axi_slave__184_/S u_axi_slave__184_/A0 sky130_fd_sc_hd__mux2_1
Xu_async_fifo_fifomem__268_ u_async_fifo_fifomem__268_/VGND u_async_fifo_fifomem__410_/VPWR
+ u_async_fifo_fifomem__410_/VPB VSUBS u_async_fifo_fifomem__268_/X u_async_fifo_fifomem__268_/A1
+ u_async_fifo_fifomem__268_/S u_async_fifo_fifomem__268_/A0 sky130_fd_sc_hd__mux2_1
Xu_async_fifo_fifomem__337_ u_async_fifo_fifomem__469_/VGND TAP_TAPCELL_ROW_17_262/VPWR
+ TAP_TAPCELL_ROW_17_262/VPWR VSUBS u_async_fifo_fifomem__337_/X u_async_fifo_fifomem__337_/A1
+ u_async_fifo_fifomem__337_/S u_async_fifo_fifomem__337_/A0 sky130_fd_sc_hd__mux2_1
XANTENNA_1 ANTENNA_1/DIODE VSUBS ANTENNA_1/VPB ANTENNA_1/VPB VSUBS sky130_fd_sc_hd__diode_2
Xclkbuf_4_8_0_s_axi_aclk clkbuf_4_8_0_s_axi_aclk/X clkbuf_4_8_0_s_axi_aclk/A clkbuf_4_9_0_s_axi_aclk/VPB
+ VSUBS VSUBS clkbuf_4_9_0_s_axi_aclk/VPB sky130_fd_sc_hd__clkbuf_8
Xu_async_fifo_rptr_empty__45_ VSUBS clkbuf_3_3__f_uart_clk/VPB clkbuf_3_3__f_uart_clk/VPB
+ VSUBS u_async_fifo_rptr_empty__45_/CLK u_async_fifo_rptr_empty__45_/D u_async_fifo_rptr_empty__45_/RESET_B
+ u_async_fifo_rptr_empty__45_/Q sky130_fd_sc_hd__dfrtp_1
Xu_axi_slave__098_ u_axi_slave__197_/VPB VSUBS VSUBS u_axi_slave__197_/VPB u_axi_slave__098_/A
+ u_axi_slave__098_/Y sky130_fd_sc_hd__clkinv_1
Xu_axi_slave__167_ VSUBS u_axi_slave__216_/VPWR u_axi_slave__216_/VPB VSUBS u_axi_slave__167_/X
+ u_axi_slave__167_/A1 u_axi_slave__167_/S u_axi_slave__167_/A0 sky130_fd_sc_hd__mux2_1
Xu_axi_slave__236_ VSUBS u_axi_slave__236_/VPB u_axi_slave__236_/VPB VSUBS u_axi_slave__236_/CLK
+ u_axi_slave__236_/D u_axi_slave__236_/RESET_B u_axi_slave__236_/Q sky130_fd_sc_hd__dfrtp_1
Xu_uart_tx__153_ VSUBS u_uart_tx__153_/VPB u_uart_tx__153_/VPB VSUBS u_uart_tx__153_/CLK
+ u_uart_tx__153_/D u_uart_tx__153_/RESET_B u_uart_tx__153_/Q sky130_fd_sc_hd__dfrtp_1
Xu_uart_tx__084_ u_uart_tx__137_/VPB VSUBS u_uart_tx__091_/VGND u_uart_tx__137_/VPB
+ u_uart_tx__084_/C u_uart_tx__084_/B u_uart_tx__084_/A u_uart_tx__084_/Y sky130_fd_sc_hd__nor3_1
Xu_async_fifo_rptr_empty__28_ VSUBS _38_/VPB u_async_fifo_rptr_empty__28_/B u_async_fifo_rptr_empty__28_/Y
+ u_async_fifo_rptr_empty__28_/A _38_/VPB VSUBS sky130_fd_sc_hd__xnor2_1
Xu_axi_slave__219_ VSUBS u_axi_slave__237_/VPB u_axi_slave__237_/VPB VSUBS u_axi_slave__219_/CLK
+ u_axi_slave__219_/D u_axi_slave__237_/RESET_B u_axi_slave__219_/Q sky130_fd_sc_hd__dfrtp_1
Xu_uart_tx__136_ VSUBS u_uart_tx__136_/VPWR u_uart_tx__136_/B u_uart_tx__136_/Y u_uart_tx__136_/A
+ u_uart_tx__136_/VPB VSUBS sky130_fd_sc_hd__xnor2_1
XPHY_EDGE_ROW_58_Left_125 PHY_EDGE_ROW_59_Left_126/VPWR PHY_EDGE_ROW_58_Left_125/VGND
+ PHY_EDGE_ROW_59_Left_126/VPB VSUBS sky130_fd_sc_hd__decap_3
XPHY_EDGE_ROW_49_Left_116 PHY_EDGE_ROW_49_Left_116/VPWR PHY_EDGE_ROW_50_Left_117/VGND
+ PHY_EDGE_ROW_49_Left_116/VPB VSUBS sky130_fd_sc_hd__decap_3
Xu_async_fifo_fifomem__370_ u_async_fifo_fifomem__370_/VGND clkbuf_4_3_0_s_axi_aclk/VPB
+ clkbuf_4_3_0_s_axi_aclk/VPB VSUBS u_async_fifo_fifomem__370_/X u_async_fifo_fifomem__370_/A1
+ u_async_fifo_fifomem__370_/S u_async_fifo_fifomem__370_/A0 sky130_fd_sc_hd__mux2_1
Xu_uart_tx__119_ VSUBS u_uart_tx__153_/VPB u_uart_tx__153_/VPB VSUBS u_uart_tx__119_/A
+ u_uart_tx__119_/X u_uart_tx__119_/B sky130_fd_sc_hd__xor2_1
Xu_async_fifo_fifomem__499_ u_async_fifo_fifomem__499_/Q u_async_fifo_fifomem__499_/CLK
+ u_async_fifo_fifomem__499_/D TAP_TAPCELL_ROW_37_403/VPWR VSUBS TAP_TAPCELL_ROW_37_403/VPWR
+ VSUBS sky130_fd_sc_hd__dfxtp_1
Xu_async_fifo_fifomem__422_ u_async_fifo_fifomem__422_/Q u_async_fifo_fifomem__422_/CLK
+ u_async_fifo_fifomem__422_/D TAP_TAPCELL_ROW_46_464/VPWR VSUBS TAP_TAPCELL_ROW_46_464/VPWR
+ VSUBS sky130_fd_sc_hd__dfxtp_1
Xu_async_fifo_fifomem__353_ VSUBS TAP_TAPCELL_ROW_35_388/VPWR TAP_TAPCELL_ROW_35_388/VPWR
+ VSUBS u_async_fifo_fifomem__353_/X u_async_fifo_fifomem__353_/A1 u_async_fifo_fifomem__353_/S
+ u_async_fifo_fifomem__353_/A0 sky130_fd_sc_hd__mux2_1
Xu_async_fifo_fifomem__284_ VSUBS TAP_TAPCELL_ROW_31_359/VPWR TAP_TAPCELL_ROW_31_359/VPWR
+ VSUBS u_async_fifo_fifomem__284_/X u_async_fifo_fifomem__284_/A1 u_async_fifo_fifomem__284_/S
+ u_async_fifo_fifomem__284_/A0 sky130_fd_sc_hd__mux2_1
Xu_async_fifo_wptr_full__39_ VSUBS u_axi_slave__217_/VPB u_axi_slave__217_/VPB VSUBS
+ u_async_fifo_wptr_full__39_/CLK u_async_fifo_wptr_full__39_/D u_async_fifo_wptr_full__39_/RESET_B
+ u_async_fifo_wptr_full__39_/Q sky130_fd_sc_hd__dfrtp_1
Xu_async_fifo_sync_w2r__6_ VSUBS TAP_TAPCELL_ROW_9_209/VPWR TAP_TAPCELL_ROW_9_209/VPWR
+ VSUBS u_async_fifo_sync_w2r__6_/CLK u_async_fifo_sync_w2r__6_/D u_async_fifo_sync_w2r__6_/RESET_B
+ u_async_fifo_sync_w2r__6_/Q sky130_fd_sc_hd__dfrtp_1
Xu_async_fifo_fifomem__198_ VSUBS TAP_TAPCELL_ROW_47_474/VPWR VSUBS TAP_TAPCELL_ROW_47_474/VPWR
+ u_async_fifo_fifomem__198_/S0 u_async_fifo_fifomem__198_/A2 u_async_fifo_fifomem__198_/A3
+ u_async_fifo_fifomem__198_/S1 u_async_fifo_fifomem__198_/A1 u_async_fifo_fifomem__198_/A0
+ u_async_fifo_fifomem__198_/X sky130_fd_sc_hd__mux4_2
Xu_async_fifo_fifomem__336_ VSUBS TAP_TAPCELL_ROW_45_458/VPWR TAP_TAPCELL_ROW_45_458/VPWR
+ VSUBS u_async_fifo_fifomem__336_/X u_async_fifo_fifomem__336_/A1 u_async_fifo_fifomem__336_/S
+ u_async_fifo_fifomem__336_/A0 sky130_fd_sc_hd__mux2_1
Xu_axi_slave__183_ VSUBS u_axi_slave__232_/VPB u_axi_slave__232_/VPB VSUBS u_axi_slave__183_/X
+ u_axi_slave__183_/A1 u_axi_slave__183_/S u_axi_slave__183_/A0 sky130_fd_sc_hd__mux2_1
Xu_async_fifo_fifomem__405_ u_async_fifo_fifomem__405_/Q u_async_fifo_fifomem__405_/CLK
+ u_async_fifo_fifomem__405_/D u_axi_slave__232_/VPB VSUBS u_axi_slave__232_/VPB VSUBS
+ sky130_fd_sc_hd__dfxtp_1
Xu_async_fifo_fifomem__267_ TAP_TAPCELL_ROW_24_312/VPWR VSUBS VSUBS TAP_TAPCELL_ROW_24_312/VPWR
+ u_async_fifo_fifomem__267_/A_N u_async_fifo_fifomem__267_/B u_async_fifo_fifomem__267_/Y
+ sky130_fd_sc_hd__nand2b_1
Xclkbuf_0_uart_clk VSUBS clkbuf_0_uart_clk/VPB VSUBS clkbuf_0_uart_clk/VPB clkbuf_0_uart_clk/A
+ clkbuf_0_uart_clk/X sky130_fd_sc_hd__clkbuf_16
XANTENNA_2 ANTENNA_2/DIODE VSUBS ANTENNA_2/VPB ANTENNA_2/VPB VSUBS sky130_fd_sc_hd__diode_2
Xu_async_fifo_rptr_empty__44_ VSUBS TAP_TAPCELL_ROW_18_271/VPWR TAP_TAPCELL_ROW_18_271/VPWR
+ VSUBS u_async_fifo_rptr_empty__44_/CLK u_async_fifo_rptr_empty__44_/D u_async_fifo_rptr_empty__44_/RESET_B
+ u_async_fifo_rptr_empty__44_/Q sky130_fd_sc_hd__dfrtp_4
Xu_axi_slave__235_ VSUBS u_axi_slave__242_/VPB u_axi_slave__242_/VPB VSUBS u_axi_slave__235_/CLK
+ u_axi_slave__235_/D u_axi_slave__235_/RESET_B u_axi_slave__235_/Q sky130_fd_sc_hd__dfrtp_1
Xu_axi_slave__097_ u_axi_slave__159_/VPB VSUBS VSUBS u_axi_slave__159_/VPB u_axi_slave__097_/A
+ u_axi_slave__097_/Y sky130_fd_sc_hd__clkinv_1
Xu_axi_slave__166_ VSUBS u_axi_slave__215_/VPB u_axi_slave__215_/VPB VSUBS u_axi_slave__166_/X
+ u_axi_slave__166_/A1 u_axi_slave__166_/S u_axi_slave__166_/A0 sky130_fd_sc_hd__mux2_1
Xu_async_fifo_fifomem__319_ VSUBS load_slew1/VPB load_slew1/VPB VSUBS u_async_fifo_fifomem__319_/X
+ u_async_fifo_fifomem__319_/A1 u_async_fifo_fifomem__319_/S u_async_fifo_fifomem__319_/A0
+ sky130_fd_sc_hd__mux2_1
Xu_uart_tx__152_ VSUBS u_uart_tx__152_/VPB u_uart_tx__152_/VPB VSUBS u_uart_tx__152_/CLK
+ u_uart_tx__152_/D u_uart_tx__152_/RESET_B u_uart_tx__152_/Q sky130_fd_sc_hd__dfrtp_1
Xu_uart_tx__083_ u_uart_tx__086_/VPB VSUBS VSUBS u_uart_tx__086_/VPB u_uart_tx__083_/A
+ u_uart_tx__083_/SLEEP u_uart_tx__083_/X sky130_fd_sc_hd__lpflow_isobufsrc_1
Xu_async_fifo_rptr_empty__27_ VSUBS clkbuf_3_3__f_uart_clk/VPB VSUBS clkbuf_3_3__f_uart_clk/VPB
+ u_async_fifo_rptr_empty__27_/X u_async_fifo_rptr_empty__27_/C u_async_fifo_rptr_empty__27_/B
+ u_async_fifo_rptr_empty__27_/A sky130_fd_sc_hd__xnor3_1
Xu_axi_slave__149_ u_axi_slave__199_/VPB u_axi_slave__153_/VGND u_axi_slave__199_/VPB
+ VSUBS u_axi_slave__149_/B2 u_axi_slave__149_/B1 u_axi_slave__149_/Y u_axi_slave__149_/A1
+ u_axi_slave__149_/A2 sky130_fd_sc_hd__a22oi_1
Xu_axi_slave__218_ VSUBS u_axi_slave__243_/VPB u_axi_slave__243_/VPB VSUBS u_axi_slave__218_/CLK
+ u_axi_slave__218_/D u_axi_slave__218_/RESET_B u_axi_slave__218_/Q sky130_fd_sc_hd__dfrtp_1
Xu_uart_tx__135_ u_uart_tx__135_/X u_uart_tx__135_/A1 u_uart_tx__135_/A2 u_uart_tx__135_/A3
+ u_uart_tx__135_/B1 u_uart_tx__135_/C1 u_uart_tx__167_/VPB VSUBS VSUBS u_uart_tx__167_/VPB
+ sky130_fd_sc_hd__o311a_1
XPHY_EDGE_ROW_25_Right_25 PHY_EDGE_ROW_25_Right_25/VPWR PHY_EDGE_ROW_26_Right_26/VGND
+ PHY_EDGE_ROW_25_Right_25/VPB VSUBS sky130_fd_sc_hd__decap_3
XPHY_EDGE_ROW_16_Right_16 TAP_TAPCELL_ROW_17_266/VPWR VSUBS TAP_TAPCELL_ROW_17_266/VPWR
+ VSUBS sky130_fd_sc_hd__decap_3
XPHY_EDGE_ROW_52_Right_52 PHY_EDGE_ROW_53_Right_53/VPWR PHY_EDGE_ROW_52_Right_52/VGND
+ PHY_EDGE_ROW_53_Right_53/VPB VSUBS sky130_fd_sc_hd__decap_3
XPHY_EDGE_ROW_43_Right_43 PHY_EDGE_ROW_43_Right_43/VPWR PHY_EDGE_ROW_44_Right_44/VGND
+ PHY_EDGE_ROW_43_Right_43/VPB VSUBS sky130_fd_sc_hd__decap_3
XPHY_EDGE_ROW_34_Right_34 u_axi_slave__244_/VPB VSUBS u_axi_slave__244_/VPB VSUBS
+ sky130_fd_sc_hd__decap_3
Xu_uart_tx__118_ u_uart_tx__153_/VPB VSUBS VSUBS u_uart_tx__153_/VPB u_uart_tx__118_/A
+ u_uart_tx__118_/Y u_uart_tx__118_/B sky130_fd_sc_hd__nand2_1
XPHY_EDGE_ROW_61_Right_61 PHY_EDGE_ROW_61_Right_61/VPWR PHY_EDGE_ROW_62_Right_62/VGND
+ PHY_EDGE_ROW_61_Right_61/VPB VSUBS sky130_fd_sc_hd__decap_3
Xu_async_fifo_fifomem__498_ u_async_fifo_fifomem__498_/Q u_async_fifo_fifomem__498_/CLK
+ u_async_fifo_fifomem__498_/D clkbuf_4_3_0_s_axi_aclk/VPB VSUBS clkbuf_4_3_0_s_axi_aclk/VPB
+ VSUBS sky130_fd_sc_hd__dfxtp_1
Xu_async_fifo_fifomem__421_ u_async_fifo_fifomem__421_/Q u_async_fifo_fifomem__421_/CLK
+ u_async_fifo_fifomem__421_/D TAP_TAPCELL_ROW_23_303/VPWR VSUBS TAP_TAPCELL_ROW_23_303/VPWR
+ VSUBS sky130_fd_sc_hd__dfxtp_1
Xu_async_fifo_wptr_full__38_ VSUBS TAP_TAPCELL_ROW_19_279/VPWR TAP_TAPCELL_ROW_19_279/VPWR
+ VSUBS u_async_fifo_wptr_full__38_/CLK u_async_fifo_wptr_full__38_/D u_async_fifo_wptr_full__38_/RESET_B
+ u_async_fifo_wptr_full__38_/Q sky130_fd_sc_hd__dfrtp_1
Xu_async_fifo_fifomem__352_ VSUBS TAP_TAPCELL_ROW_28_338/VPWR TAP_TAPCELL_ROW_28_338/VPWR
+ VSUBS u_async_fifo_fifomem__352_/X u_async_fifo_fifomem__352_/A1 u_async_fifo_fifomem__352_/S
+ u_async_fifo_fifomem__352_/A0 sky130_fd_sc_hd__mux2_1
Xu_async_fifo_fifomem__283_ VSUBS TAP_TAPCELL_ROW_23_303/VPWR TAP_TAPCELL_ROW_23_303/VPWR
+ VSUBS u_async_fifo_fifomem__283_/X u_async_fifo_fifomem__283_/A1 u_async_fifo_fifomem__283_/S
+ u_async_fifo_fifomem__283_/A0 sky130_fd_sc_hd__mux2_1
Xu_async_fifo_sync_w2r__5_ VSUBS u_axi_slave__217_/VPB u_axi_slave__217_/VPB VSUBS
+ u_async_fifo_sync_w2r__5_/CLK u_async_fifo_sync_w2r__5_/D u_async_fifo_sync_w2r__5_/RESET_B
+ u_async_fifo_sync_w2r__5_/Q sky130_fd_sc_hd__dfrtp_1
Xu_async_fifo_fifomem__404_ u_async_fifo_fifomem__404_/Q u_async_fifo_fifomem__404_/CLK
+ u_async_fifo_fifomem__404_/D TAP_TAPCELL_ROW_47_474/VPWR VSUBS TAP_TAPCELL_ROW_47_474/VPWR
+ VSUBS sky130_fd_sc_hd__dfxtp_1
Xu_async_fifo_fifomem__197_ VSUBS TAP_TAPCELL_ROW_44_452/VPWR VSUBS TAP_TAPCELL_ROW_44_452/VPWR
+ u_async_fifo_fifomem__197_/S0 u_async_fifo_fifomem__197_/A2 u_async_fifo_fifomem__197_/A3
+ u_async_fifo_fifomem__197_/S1 u_async_fifo_fifomem__197_/A1 u_async_fifo_fifomem__197_/A0
+ u_async_fifo_fifomem__197_/X sky130_fd_sc_hd__mux4_2
Xu_async_fifo_fifomem__266_ VSUBS TAP_TAPCELL_ROW_43_446/VPWR TAP_TAPCELL_ROW_43_446/VPWR
+ VSUBS u_async_fifo_fifomem__266_/X u_async_fifo_fifomem__266_/A1 u_async_fifo_fifomem__266_/S
+ u_async_fifo_fifomem__266_/A0 sky130_fd_sc_hd__mux2_1
Xu_async_fifo_fifomem__335_ VSUBS TAP_TAPCELL_ROW_37_402/VPWR TAP_TAPCELL_ROW_37_402/VPWR
+ VSUBS u_async_fifo_fifomem__335_/X u_async_fifo_fifomem__335_/A1 u_async_fifo_fifomem__335_/S
+ u_async_fifo_fifomem__335_/A0 sky130_fd_sc_hd__mux2_1
Xu_axi_slave__182_ VSUBS u_axi_slave__209_/VPB u_axi_slave__209_/VPB VSUBS u_axi_slave__182_/X
+ u_axi_slave__182_/A1 u_axi_slave__182_/S u_axi_slave__182_/A0 sky130_fd_sc_hd__mux2_1
XPHY_EDGE_ROW_2_Right_2 PHY_EDGE_ROW_3_Right_3/VPWR PHY_EDGE_ROW_2_Right_2/VGND PHY_EDGE_ROW_3_Right_3/VPB
+ VSUBS sky130_fd_sc_hd__decap_3
Xu_async_fifo_rptr_empty__43_ VSUBS TAP_TAPCELL_ROW_15_251/VPWR TAP_TAPCELL_ROW_15_251/VPWR
+ VSUBS u_async_fifo_rptr_empty__43_/CLK u_async_fifo_rptr_empty__43_/D u_async_fifo_rptr_empty__43_/RESET_B
+ u_async_fifo_rptr_empty__43_/Q sky130_fd_sc_hd__dfrtp_1
Xu_async_fifo_fifomem__318_ VSUBS TAP_TAPCELL_ROW_48_481/VPWR TAP_TAPCELL_ROW_48_481/VPWR
+ VSUBS u_async_fifo_fifomem__318_/X u_async_fifo_fifomem__318_/A1 u_async_fifo_fifomem__318_/S
+ u_async_fifo_fifomem__318_/A0 sky130_fd_sc_hd__mux2_1
Xu_axi_slave__234_ VSUBS u_axi_slave__244_/VPB u_axi_slave__244_/VPB VSUBS u_axi_slave__234_/CLK
+ u_axi_slave__234_/D u_axi_slave__234_/RESET_B u_axi_slave__234_/Q sky130_fd_sc_hd__dfrtp_1
Xu_axi_slave__165_ VSUBS u_axi_slave__230_/VPB u_axi_slave__230_/VPB VSUBS u_axi_slave__165_/X
+ u_axi_slave__165_/A1 u_axi_slave__165_/S u_axi_slave__165_/A0 sky130_fd_sc_hd__mux2_1
Xu_async_fifo_fifomem__249_ VSUBS clkbuf_4_3_0_s_axi_aclk/VPB clkbuf_4_3_0_s_axi_aclk/VPB
+ VSUBS u_async_fifo_fifomem__249_/X u_async_fifo_fifomem__249_/A1 u_async_fifo_fifomem__249_/S
+ u_async_fifo_fifomem__249_/A0 sky130_fd_sc_hd__mux2_1
Xu_async_fifo_rptr_empty__26_ VSUBS TAP_TAPCELL_ROW_18_271/VPWR u_async_fifo_rptr_empty__26_/B
+ u_async_fifo_rptr_empty__26_/Y u_async_fifo_rptr_empty__26_/A TAP_TAPCELL_ROW_18_271/VPWR
+ VSUBS sky130_fd_sc_hd__xnor2_1
Xu_uart_tx__082_ u_uart_tx__136_/VPB VSUBS VSUBS u_uart_tx__136_/VPWR u_uart_tx__082_/A
+ u_uart_tx__082_/Y u_uart_tx__082_/B sky130_fd_sc_hd__nand2_1
Xu_uart_tx__151_ VSUBS u_uart_tx__153_/VPB u_uart_tx__153_/VPB VSUBS u_uart_tx__151_/CLK
+ u_uart_tx__151_/D u_uart_tx__153_/RESET_B u_uart_tx__151_/Q sky130_fd_sc_hd__dfrtp_1
Xu_axi_slave__148_ VSUBS u_axi_slave__209_/VPB u_axi_slave__209_/VPB VSUBS u_axi_slave__148_/A3
+ u_axi_slave__148_/A2 u_axi_slave__148_/A1 u_axi_slave__148_/Y u_axi_slave__148_/B1
+ sky130_fd_sc_hd__a31oi_1
Xu_axi_slave__217_ u_axi_slave__217_/VGND u_axi_slave__217_/VPB u_axi_slave__217_/VPB
+ VSUBS u_axi_slave__217_/CLK u_axi_slave__217_/D u_axi_slave__217_/RESET_B u_axi_slave__217_/Q
+ sky130_fd_sc_hd__dfrtp_1
Xu_uart_tx__134_ u_uart_tx__167_/VPB VSUBS u_uart_tx__134_/A1 u_uart_tx__134_/A2 u_uart_tx__134_/A3
+ u_uart_tx__134_/Y u_uart_tx__134_/B1 u_uart_tx__167_/VPB VSUBS sky130_fd_sc_hd__o31ai_1
Xu_uart_tx__117_ u_uart_tx__152_/VPB VSUBS VSUBS u_uart_tx__152_/VPB u_uart_tx__117_/C
+ u_uart_tx__117_/B u_uart_tx__117_/A u_uart_tx__117_/Y sky130_fd_sc_hd__nor3_1
Xu_async_fifo_fifomem__497_ u_async_fifo_fifomem__497_/Q u_async_fifo_fifomem__497_/CLK
+ u_async_fifo_fifomem__497_/D clkbuf_4_7_0_s_axi_aclk/VPB VSUBS clkbuf_4_7_0_s_axi_aclk/VPB
+ VSUBS sky130_fd_sc_hd__dfxtp_1
Xu_async_fifo_fifomem__420_ u_async_fifo_fifomem__420_/Q u_async_fifo_fifomem__420_/CLK
+ u_async_fifo_fifomem__420_/D u_async_fifo_fifomem__420_/VPB VSUBS u_async_fifo_fifomem__420_/VPWR
+ VSUBS sky130_fd_sc_hd__dfxtp_1
Xu_async_fifo_fifomem__282_ VSUBS TAP_TAPCELL_ROW_46_464/VPWR TAP_TAPCELL_ROW_46_464/VPWR
+ VSUBS u_async_fifo_fifomem__282_/X u_async_fifo_fifomem__282_/A1 u_async_fifo_fifomem__282_/S
+ u_async_fifo_fifomem__282_/A0 sky130_fd_sc_hd__mux2_1
Xu_async_fifo_fifomem__351_ TAP_TAPCELL_ROW_23_304/VPWR VSUBS VSUBS TAP_TAPCELL_ROW_23_304/VPWR
+ u_async_fifo_fifomem__351_/D_N u_async_fifo_fifomem__351_/C u_async_fifo_fifomem__351_/Y
+ u_async_fifo_fifomem__351_/B u_async_fifo_fifomem__351_/A sky130_fd_sc_hd__nor4b_1
Xu_async_fifo_wptr_full__37_ TAP_TAPCELL_ROW_17_265/VPWR VSUBS VSUBS TAP_TAPCELL_ROW_17_265/VPWR
+ u_async_fifo_wptr_full__37_/B_N u_async_fifo_wptr_full__37_/A u_async_fifo_wptr_full__37_/Y
+ sky130_fd_sc_hd__nor2b_1
XPHY_EDGE_ROW_28_Left_95 PHY_EDGE_ROW_29_Left_96/VPWR PHY_EDGE_ROW_28_Left_95/VGND
+ PHY_EDGE_ROW_29_Left_96/VPB VSUBS sky130_fd_sc_hd__decap_3
Xu_async_fifo_sync_w2r__4_ VSUBS TAP_TAPCELL_ROW_13_238/VPWR TAP_TAPCELL_ROW_13_238/VPWR
+ VSUBS u_async_fifo_sync_w2r__4_/CLK u_async_fifo_sync_w2r__4_/D u_async_fifo_sync_w2r__4_/RESET_B
+ u_async_fifo_sync_w2r__4_/Q sky130_fd_sc_hd__dfrtp_1
Xu_async_fifo_fifomem__403_ u_async_fifo_fifomem__403_/Q u_async_fifo_fifomem__403_/CLK
+ u_async_fifo_fifomem__403_/D u_axi_slave__199_/VPB VSUBS u_axi_slave__199_/VPB VSUBS
+ sky130_fd_sc_hd__dfxtp_1
Xu_async_fifo_fifomem__334_ u_async_fifo_fifomem__466_/VGND u_async_fifo_fifomem__334_/VPWR
+ u_async_fifo_fifomem__334_/VPB VSUBS u_async_fifo_fifomem__334_/X u_async_fifo_fifomem__334_/A1
+ u_async_fifo_fifomem__334_/S u_async_fifo_fifomem__334_/A0 sky130_fd_sc_hd__mux2_1
XPHY_EDGE_ROW_12_Left_79 PHY_EDGE_ROW_13_Left_80/VPWR PHY_EDGE_ROW_12_Left_79/VGND
+ PHY_EDGE_ROW_13_Left_80/VPB VSUBS sky130_fd_sc_hd__decap_3
Xu_async_fifo_fifomem__196_ VSUBS TAP_TAPCELL_ROW_51_501/VPWR u_async_fifo_fifomem__363_/VGND
+ TAP_TAPCELL_ROW_51_501/VPWR u_async_fifo_fifomem__196_/S0 u_async_fifo_fifomem__196_/A2
+ u_async_fifo_fifomem__196_/A3 u_async_fifo_fifomem__196_/S1 u_async_fifo_fifomem__196_/A1
+ u_async_fifo_fifomem__196_/A0 u_async_fifo_fifomem__196_/X sky130_fd_sc_hd__mux4_2
Xu_async_fifo_fifomem__265_ VSUBS TAP_TAPCELL_ROW_32_369/VPWR TAP_TAPCELL_ROW_32_369/VPWR
+ VSUBS u_async_fifo_fifomem__265_/X u_async_fifo_fifomem__265_/A1 u_async_fifo_fifomem__265_/S
+ u_async_fifo_fifomem__265_/A0 sky130_fd_sc_hd__mux2_1
Xu_axi_slave__181_ VSUBS ANTENNA_2/VPB ANTENNA_2/VPB VSUBS u_axi_slave__181_/X u_axi_slave__181_/A1
+ u_axi_slave__181_/S u_axi_slave__181_/A0 sky130_fd_sc_hd__mux2_1
Xu_async_fifo_rptr_empty__42_ VSUBS clkbuf_0_uart_clk/VPB clkbuf_0_uart_clk/VPB VSUBS
+ u_async_fifo_rptr_empty__42_/CLK u_async_fifo_rptr_empty__42_/D u_async_fifo_rptr_empty__42_/RESET_B
+ u_async_fifo_rptr_empty__42_/Q sky130_fd_sc_hd__dfrtp_1
Xu_async_fifo_fifomem__317_ VSUBS TAP_TAPCELL_ROW_38_411/VPWR TAP_TAPCELL_ROW_38_411/VPWR
+ VSUBS u_async_fifo_fifomem__317_/X u_async_fifo_fifomem__317_/A1 u_async_fifo_fifomem__317_/S
+ u_async_fifo_fifomem__317_/A0 sky130_fd_sc_hd__mux2_1
Xu_axi_slave__164_ VSUBS u_axi_slave__180_/VPB u_axi_slave__180_/VPB VSUBS u_axi_slave__164_/X
+ u_axi_slave__164_/A1 u_axi_slave__164_/S u_axi_slave__164_/A0 sky130_fd_sc_hd__mux2_1
Xu_axi_slave__233_ VSUBS u_axi_slave__233_/VPB u_axi_slave__233_/VPB VSUBS u_axi_slave__233_/CLK
+ u_axi_slave__233_/D u_axi_slave__233_/RESET_B u_axi_slave__233_/Q sky130_fd_sc_hd__dfrtp_1
Xu_async_fifo_fifomem__248_ TAP_TAPCELL_ROW_23_304/VPWR VSUBS TAP_TAPCELL_ROW_23_304/VPWR
+ VSUBS u_async_fifo_fifomem__248_/B u_async_fifo_fifomem__248_/C u_async_fifo_fifomem__248_/A
+ u_async_fifo_fifomem__248_/X sky130_fd_sc_hd__or3_1
Xu_uart_tx__081_ VSUBS u_uart_tx__136_/VPB VSUBS u_uart_tx__136_/VPWR u_uart_tx__081_/B1
+ u_uart_tx__081_/A1 u_uart_tx__081_/Y u_uart_tx__081_/A2 sky130_fd_sc_hd__o21ai_0
Xu_uart_tx__150_ VSUBS u_uart_tx__150_/VPB u_uart_tx__150_/VPB VSUBS u_uart_tx__150_/CLK
+ u_uart_tx__150_/D u_uart_tx__150_/RESET_B u_uart_tx__150_/Q sky130_fd_sc_hd__dfrtp_1
Xu_async_fifo_rptr_empty__25_ VSUBS clkbuf_3_3__f_uart_clk/VPB u_async_fifo_rptr_empty__25_/B
+ u_async_fifo_rptr_empty__25_/Y u_async_fifo_rptr_empty__25_/A clkbuf_3_3__f_uart_clk/VPB
+ VSUBS sky130_fd_sc_hd__xnor2_1
.ends
